* NGSPICE file created from tt_um_lelo_gr02_analogicus.ext - technology: sky130A

* Replacing the lpe port list (../tech/scripts/fixlpe)
.subckt tt_um_lelo_gr02_analogicus uo_out<7> uo_out<6> uo_out<5> uo_out<4> uo_out<3> uo_out<2> uo_out<1> uo_out<0>
+ uio_out<7> uio_out<6> uio_out<5> uio_out<4> uio_out<3> uio_out<2> uio_out<1> uio_out<0> uio_oe<7> uio_oe<6> uio_oe<5> uio_oe<4> uio_oe<3> uio_oe<2> uio_oe<1> uio_oe<0> VDPWR VGND
+ ui_in<7> ui_in<6> ui_in<5> ui_in<4> ui_in<3> ui_in<2> ui_in<1> ui_in<0> uio_in<7> uio_in<6> uio_in<5> uio_in<4> uio_in<3> uio_in<2> uio_in<1> uio_in<0> ena rst_n clk
*.subckt tt_um_lelo_gr02_analogicus uo_out<7> uo_out<6> uo_out<5> uo_out<4> uo_out<3>
*+ uo_out<2> uo_out<1> uo_out<0> uio_out<7> uio_out<6> uio_out<5> uio_out<4> uio_out<3>
*+ uio_out<2> uio_out<1> uio_out<0> uio_oe<7> uio_oe<6> uio_oe<5> uio_oe<4> uio_oe<3>
*+ uio_oe<2> uio_oe<1> uio_oe<0> VDPWR VGND ui_in<7> ui_in<6> ui_in<5> ui_in<4> ui_in<3>
*+ ui_in<2> ui_in<1> ui_in<0> uio_in<7> uio_in<6> uio_in<5> uio_in<4> uio_in<3> uio_in<2>
*+ uio_in<1> uio_in<0> ena rst_n clk
X0 LELO_GR02_0.OSCILLATOR_0.x5.x11.G LELO_GR02_0.OSCILLATOR_0.V_CTAT LELO_GR02_0.OSCILLATOR_0.x5.x9<4>.S VGND sky130_fd_pr__nfet_01v8 ad=0.528 pd=2.26 as=0.848 ps=4.26 w=1.6 l=0.94
X1 LELO_GR02_0.BANDGAP_0.x5.B LELO_GR02_0.BANDGAP_0.x5.A sky130_fd_pr__cap_mim_m3_1 l=5 w=5
X2 LELO_GR02_0.OSCILLATOR_0.PWRUP_N_1V8 ui_in<0> VDPWR VDPWR sky130_fd_pr__pfet_01v8 ad=0.468 pd=2.84 as=0.468 ps=2.84 w=0.9 l=0.16
X3 LELO_GR02_0.BANDGAP_0.x2.LELOATR_PCH_12C5F0_7.G LELO_GR02_0.BANDGAP_0.x2.LELOATR_PCH_12C5F0_7.G LELO_GR02_0.BANDGAP_0.x2.x2.P VDPWR sky130_fd_pr__pfet_01v8 ad=1.3728 pd=4.82 as=2.2048 ps=9.38 w=4.16 l=0.94
X4 LELO_GR02_0.BANDGAP_0.x2.x2.P LELO_GR02_0.BANDGAP_0.x2.LELOATR_PCH_12C5F0_7.G LELO_GR02_0.BANDGAP_0.x2.x2<1>.A VDPWR sky130_fd_pr__pfet_01v8 ad=2.2048 pd=9.38 as=1.3728 ps=4.82 w=4.16 l=0.94
X5 LELO_GR02_0.OSCILLATOR_0.x13<2>.B LELO_GR02_0.OSCILLATOR_0.x6.CK LELO_GR02_0.OSCILLATOR_0.I_PTAT VGND sky130_fd_pr__nfet_01v8 ad=0.3168 pd=1.62 as=0.5088 ps=2.98 w=0.96 l=0.94
X6 LELO_GR02_0.OSCILLATOR_0.x5.x9<4>.D LELO_GR02_0.OSCILLATOR_0.I_PTAT LELO_GR02_0.OSCILLATOR_0.x5.x9<4>.S VGND sky130_fd_pr__nfet_01v8 ad=0.528 pd=2.26 as=0.848 ps=4.26 w=1.6 l=0.94
X7 VGND LELO_GR02_0.BANDGAP_0.x2.x6.D LELO_GR02_0.BANDGAP_0.x5.B VGND sky130_fd_pr__nfet_01v8 ad=0.848 pd=4.26 as=0.528 ps=2.26 w=1.6 l=0.94
X8 LELO_GR02_0.OSCILLATOR_0.PWRUP_B_1V8 LELO_GR02_0.OSCILLATOR_0.PWRUP_N_1V8 VGND VGND sky130_fd_pr__nfet_01v8 ad=0.468 pd=2.84 as=0.468 ps=2.84 w=0.9 l=0.16
X9 LELO_GR02_0.OSCILLATOR_0.x5.x11.S LELO_GR02_0.OSCILLATOR_0.x5.x11.G LELO_GR02_0.OSCILLATOR_0.x5.x9<4>.D VDPWR sky130_fd_pr__pfet_01v8 ad=0.848 pd=4.26 as=0.528 ps=2.26 w=1.6 l=0.94
X10 LELO_GR02_0.OSCILLATOR_0.x6.D LELO_GR02_0.OSCILLATOR_0.x6.XA7.CN LELO_GR02_0.OSCILLATOR_0.x6.XA6.MN1.S VGND sky130_fd_pr__nfet_01v8 ad=0.468 pd=2.84 as=0.288 ps=1.54 w=0.9 l=0.16
X11 LELO_GR02_0.BANDGAP_0.x2.LELOATR_NCH_4C5F0_5.D LELO_GR02_0.BANDGAP_0.x2.x6.D VGND VGND sky130_fd_pr__nfet_01v8 ad=0.528 pd=2.26 as=0.848 ps=4.26 w=1.6 l=0.94
X12 LELO_GR02_0.OSCILLATOR_0.x5.x11.S LELO_GR02_0.OSCILLATOR_0.PWRUP_N_1V8 VDPWR VDPWR sky130_fd_pr__pfet_01v8 ad=0.8352 pd=3.46 as=1.4112 ps=6.74 w=2.88 l=0.22
X13 LELO_GR02_0.BANDGAP_0.x5.A LELO_GR02_0.BANDGAP_0.x5.B LELO_GR02_0.OSCILLATOR_0.I_PTAT VDPWR sky130_fd_pr__pfet_01v8 ad=0.4704 pd=2.9 as=0.2784 ps=1.54 w=0.96 l=0.22
X14 LELO_GR02_0.OSCILLATOR_0.x6.XA7.C LELO_GR02_0.OSCILLATOR_0.x6.CK VDPWR VDPWR sky130_fd_pr__pfet_01v8 ad=0.288 pd=1.54 as=0.468 ps=2.84 w=0.9 l=0.16
X15 LELO_GR02_0.OSCILLATOR_0.x5.x11.G LELO_GR02_0.OSCILLATOR_0.x5.x11.G LELO_GR02_0.OSCILLATOR_0.x5.x11.S VDPWR sky130_fd_pr__pfet_01v8 ad=0.528 pd=2.26 as=0.848 ps=4.26 w=1.6 l=0.94
X16 LELO_GR02_0.OSCILLATOR_0.x13<2>.B LELO_GR02_0.OSCILLATOR_0.I_PTAT sky130_fd_pr__cap_mim_m3_1 l=5 w=5
R0 uio_oe<2> JNWTR_TIEL_CV_0.Y sky130_fd_pr__res_generic_m4 w=0.3 l=0.3
X17 LELO_GR02_0.OSCILLATOR_0.x13<2>.B LELO_GR02_0.OSCILLATOR_0.I_PTAT sky130_fd_pr__cap_mim_m3_1 l=5 w=5
X18 LELO_GR02_0.BANDGAP_0.x2.x2.P LELO_GR02_0.BANDGAP_0.x2.LELOATR_PCH_12C5F0_7.G LELO_GR02_0.BANDGAP_0.x2.LELOATR_PCH_12C5F0_7.G VDPWR sky130_fd_pr__pfet_01v8 ad=2.2048 pd=9.38 as=1.3728 ps=4.82 w=4.16 l=0.94
X19 LELO_GR02_0.BANDGAP_0.x5.B LELO_GR02_0.BANDGAP_0.x2.x2<1>.A LELO_GR02_0.BANDGAP_0.x2.x2.P VDPWR sky130_fd_pr__pfet_01v8 ad=1.3728 pd=4.82 as=2.2048 ps=9.38 w=4.16 l=0.94
X20 VGND LELO_GR02_0.BANDGAP_0.x2.x6.D LELO_GR02_0.BANDGAP_0.x5.B VGND sky130_fd_pr__nfet_01v8 ad=0.848 pd=4.26 as=0.528 ps=2.26 w=1.6 l=0.94
X21 LELO_GR02_0.BANDGAP_0.x5.B LELO_GR02_0.BANDGAP_0.x2.x2<1>.A sky130_fd_pr__cap_mim_m3_1 l=5 w=5
X22 LELO_GR02_0.BANDGAP_0.x2.x2.P LELO_GR02_0.OSCILLATOR_0.PWRUP_N_1V8 VDPWR VDPWR sky130_fd_pr__pfet_01v8 ad=0.8352 pd=3.46 as=1.4112 ps=6.74 w=2.88 l=0.22
X23 VGND LELO_GR02_0.OSCILLATOR_0.PWRUP_B_1V8 LELO_GR02_0.OSCILLATOR_0.x13<2>.B VGND sky130_fd_pr__nfet_01v8 ad=1.4112 pd=6.74 as=0.8352 ps=3.46 w=2.88 l=0.22
X24 LELO_GR02_0.BANDGAP_0.x2.x2.P LELO_GR02_0.BANDGAP_0.x2.x2<1>.A LELO_GR02_0.BANDGAP_0.x5.B VDPWR sky130_fd_pr__pfet_01v8 ad=2.2048 pd=9.38 as=1.3728 ps=4.82 w=4.16 l=0.94
X25 LELO_GR02_0.BANDGAP_0.x5.B LELO_GR02_0.BANDGAP_0.x2.x2<1>.A sky130_fd_pr__cap_mim_m3_1 l=5 w=5
X26 LELO_GR02_0.OSCILLATOR_0.x5.x9<4>.S LELO_GR02_0.OSCILLATOR_0.V_CTAT LELO_GR02_0.OSCILLATOR_0.x5.x11.G VGND sky130_fd_pr__nfet_01v8 ad=0.848 pd=4.26 as=0.528 ps=2.26 w=1.6 l=0.94
X27 LELO_GR02_0.BANDGAP_0.x2.x2.P a_6707_3790# VGND sky130_fd_pr__res_high_po w=0.36 l=7.36
X28 LELO_GR02_0.BANDGAP_0.x2.x2<1>.A LELO_GR02_0.BANDGAP_0.x2.LELOATR_PCH_12C5F0_7.G LELO_GR02_0.BANDGAP_0.x2.x2.P VDPWR sky130_fd_pr__pfet_01v8 ad=1.3728 pd=4.82 as=2.2048 ps=9.38 w=4.16 l=0.94
X29 LELO_GR02_0.OSCILLATOR_0.x5.x9<4>.D LELO_GR02_0.OSCILLATOR_0.I_PTAT LELO_GR02_0.OSCILLATOR_0.x5.x9<4>.S VGND sky130_fd_pr__nfet_01v8 ad=0.528 pd=2.26 as=0.848 ps=4.26 w=1.6 l=0.94
X30 LELO_GR02_0.OSCILLATOR_0.x13<2>.B LELO_GR02_0.OSCILLATOR_0.I_PTAT sky130_fd_pr__cap_mim_m3_1 l=5 w=5
X31 LELO_GR02_0.BANDGAP_0.x2.x6.D LELO_GR02_0.BANDGAP_0.x2.x6.D VGND VGND sky130_fd_pr__nfet_01v8 ad=0.528 pd=2.26 as=0.848 ps=4.26 w=1.6 l=0.94
X32 LELO_GR02_0.OSCILLATOR_0.I_PTAT LELO_GR02_0.BANDGAP_0.x5.B LELO_GR02_0.BANDGAP_0.x5.A VDPWR sky130_fd_pr__pfet_01v8 ad=0.2784 pd=1.54 as=0.4704 ps=2.9 w=0.96 l=0.22
X33 LELO_GR02_0.OSCILLATOR_0.x5.x7.G LELO_GR02_0.OSCILLATOR_0.PWRUP_N_1V8 VGND VGND sky130_fd_pr__nfet_01v8 ad=0.8352 pd=3.46 as=1.4112 ps=6.74 w=2.88 l=0.22
X34 LELO_GR02_0.BANDGAP_0.x2.LELOATR_PCH_12C5F0_7.G LELO_GR02_0.BANDGAP_0.x2.LELOATR_PCH_12C5F0_7.G LELO_GR02_0.BANDGAP_0.x2.x2.P VDPWR sky130_fd_pr__pfet_01v8 ad=1.3728 pd=4.82 as=2.2048 ps=9.38 w=4.16 l=0.94
X35 LELO_GR02_0.BANDGAP_0.x5.B LELO_GR02_0.BANDGAP_0.x2.x2<1>.A sky130_fd_pr__cap_mim_m3_1 l=5 w=5
X36 LELO_GR02_0.OSCILLATOR_0.x6.XA7.CN LELO_GR02_0.OSCILLATOR_0.x6.XA7.C VDPWR VDPWR sky130_fd_pr__pfet_01v8 ad=0.468 pd=2.84 as=0.468 ps=2.84 w=0.9 l=0.16
X37 VGND VGND LELO_GR02_0.BANDGAP_0.x8.DN sky130_fd_pr__pnp_05v5_W3p40L3p40
**devattr s=462400,2720
X38 LELO_GR02_0.OSCILLATOR_0.x13<2>.B LELO_GR02_0.OSCILLATOR_0.I_PTAT sky130_fd_pr__cap_mim_m3_1 l=5 w=5
X39 a_19510_4886# a_19294_2966# VGND sky130_fd_pr__res_high_po w=0.36 l=7.36
X40 VGND VGND VGND VGND sky130_fd_pr__nfet_01v8 ad=0.468 pd=2.84 as=102.5352 ps=547.52002 w=0.9 l=0.16
X41 LELO_GR02_0.BANDGAP_0.x2.x2<1>.A LELO_GR02_0.BANDGAP_0.x4.D LELO_GR02_0.BANDGAP_0.x2.LELOATR_NCH_4C5F0_5.D VGND sky130_fd_pr__nfet_01v8 ad=0.528 pd=2.26 as=0.848 ps=4.26 w=1.6 l=0.94
R1 uio_oe<3> JNWTR_TIEL_CV_0.Y sky130_fd_pr__res_generic_m4 w=0.3 l=0.3
X42 LELO_GR02_0.OSCILLATOR_0.x6.CK LELO_GR02_0.OSCILLATOR_0.PWRUP_N_1V8 VGND VGND sky130_fd_pr__nfet_01v8 ad=0.8352 pd=3.46 as=1.4112 ps=6.74 w=2.88 l=0.22
X43 a_6491_5710# a_6707_3790# VGND sky130_fd_pr__res_high_po w=0.36 l=7.36
X44 LELO_GR02_0.BANDGAP_0.x2.x6.D LELO_GR02_0.BANDGAP_0.x2.x6.D VGND VGND sky130_fd_pr__nfet_01v8 ad=0.528 pd=2.26 as=0.848 ps=4.26 w=1.6 l=0.94
X45 LELO_GR02_0.OSCILLATOR_0.x13<2>.B LELO_GR02_0.OSCILLATOR_0.I_PTAT sky130_fd_pr__cap_mim_m3_1 l=5 w=5
X46 LELO_GR02_0.OSCILLATOR_0.x13<2>.B LELO_GR02_0.OSCILLATOR_0.I_PTAT sky130_fd_pr__cap_mim_m3_1 l=5 w=5
X47 LELO_GR02_0.OSCILLATOR_0.x6.XA4.MP1.S LELO_GR02_0.OSCILLATOR_0.x6.XA6.A VDPWR VDPWR sky130_fd_pr__pfet_01v8 ad=0.288 pd=1.54 as=0.468 ps=2.84 w=0.9 l=0.16
X48 LELO_GR02_0.BANDGAP_0.x2.LELOATR_NCH_4C5F0_5.D LELO_GR02_0.OSCILLATOR_0.V_CTAT LELO_GR02_0.BANDGAP_0.x2.LELOATR_PCH_12C5F0_7.G VGND sky130_fd_pr__nfet_01v8 ad=0.848 pd=4.26 as=0.528 ps=2.26 w=1.6 l=0.94
X49 LELO_GR02_0.BANDGAP_0.x4.D a_12542_9428# VGND sky130_fd_pr__res_high_po w=0.36 l=7.36
X50 LELO_GR02_0.OSCILLATOR_0.x6.XA3.MN1.S LELO_GR02_0.OSCILLATOR_0.x6.D VGND VGND sky130_fd_pr__nfet_01v8 ad=0.288 pd=1.54 as=0.468 ps=2.84 w=0.9 l=0.16
X51 LELO_GR02_0.OSCILLATOR_0.x6.XA5.A LELO_GR02_0.OSCILLATOR_0.x6.XA7.CN LELO_GR02_0.OSCILLATOR_0.x6.XA3.MP1.S VDPWR sky130_fd_pr__pfet_01v8 ad=0.468 pd=2.84 as=0.288 ps=1.54 w=0.9 l=0.16
X52 LELO_GR02_0.OSCILLATOR_0.x13<2>.B LELO_GR02_0.OSCILLATOR_0.PWRUP_B_1V8 VGND VGND sky130_fd_pr__nfet_01v8 ad=0.8352 pd=3.46 as=1.4112 ps=6.74 w=2.88 l=0.22
X53 LELO_GR02_0.OSCILLATOR_0.x5.x9<4>.S LELO_GR02_0.OSCILLATOR_0.I_PTAT LELO_GR02_0.OSCILLATOR_0.x5.x9<4>.D VGND sky130_fd_pr__nfet_01v8 ad=0.848 pd=4.26 as=0.528 ps=2.26 w=1.6 l=0.94
R2 uio_oe<1> JNWTR_TIEL_CV_0.Y sky130_fd_pr__res_generic_m4 w=0.3 l=0.3
X54 LELO_GR02_0.BANDGAP_0.x2.x6.D a_5411_3790# VGND sky130_fd_pr__res_high_po w=0.36 l=7.36
X55 VGND VGND VGND VGND sky130_fd_pr__nfet_01v8 ad=0.468 pd=2.84 as=0 ps=0 w=0.9 l=0.16
X56 LELO_GR02_0.BANDGAP_0.x2.x2.P LELO_GR02_0.BANDGAP_0.x2.x2<1>.A LELO_GR02_0.BANDGAP_0.x5.B VDPWR sky130_fd_pr__pfet_01v8 ad=2.2048 pd=9.38 as=1.3728 ps=4.82 w=4.16 l=0.94
X57 VGND LELO_GR02_0.OSCILLATOR_0.PWRUP_N_1V8 LELO_GR02_0.OSCILLATOR_0.x6.CK VGND sky130_fd_pr__nfet_01v8 ad=1.4112 pd=6.74 as=0.8352 ps=3.46 w=2.88 l=0.22
X58 LELO_GR02_0.OSCILLATOR_0.x6.XA7.C LELO_GR02_0.OSCILLATOR_0.PWRUP_B_1V8 LELO_GR02_0.OSCILLATOR_0.x6.XA1.MN1.S VGND sky130_fd_pr__nfet_01v8 ad=0.468 pd=2.84 as=0.288 ps=1.54 w=0.9 l=0.16
X59 LELO_GR02_0.OSCILLATOR_0.x5.x7.G LELO_GR02_0.OSCILLATOR_0.x5.x7.G VGND VGND sky130_fd_pr__nfet_01v8 ad=0.528 pd=2.26 as=0.848 ps=4.26 w=1.6 l=0.94
X60 LELO_GR02_0.OSCILLATOR_0.I_PTAT LELO_GR02_0.BANDGAP_0.x5.B LELO_GR02_0.BANDGAP_0.x5.A VDPWR sky130_fd_pr__pfet_01v8 ad=0.2784 pd=1.54 as=0.4704 ps=2.9 w=0.96 l=0.22
X61 a_17782_4886# a_17566_2966# VGND sky130_fd_pr__res_high_po w=0.36 l=7.36
X62 LELO_GR02_0.OSCILLATOR_0.x6.CK LELO_GR02_0.OSCILLATOR_0.x5.x9<4>.D LELO_GR02_0.OSCILLATOR_0.x5.x11.S VDPWR sky130_fd_pr__pfet_01v8_lvt ad=0.528 pd=2.26 as=0.848 ps=4.26 w=1.6 l=0.94
X63 LELO_GR02_0.BANDGAP_0.x2.x2<1>.A LELO_GR02_0.BANDGAP_0.x2.LELOATR_PCH_12C5F0_7.G LELO_GR02_0.BANDGAP_0.x2.x2.P VDPWR sky130_fd_pr__pfet_01v8 ad=1.3728 pd=4.82 as=2.2048 ps=9.38 w=4.16 l=0.94
X64 LELO_GR02_0.BANDGAP_0.x5.B LELO_GR02_0.OSCILLATOR_0.PWRUP_N_1V8 VGND VGND sky130_fd_pr__nfet_01v8 ad=0.8352 pd=3.46 as=1.4112 ps=6.74 w=2.88 l=0.22
X65 LELO_GR02_0.OSCILLATOR_0.x5.x9<4>.S LELO_GR02_0.OSCILLATOR_0.V_CTAT LELO_GR02_0.OSCILLATOR_0.x5.x11.G VGND sky130_fd_pr__nfet_01v8 ad=0.848 pd=4.26 as=0.528 ps=2.26 w=1.6 l=0.94
R3 uio_oe<7> JNWTR_TIEL_CV_0.Y sky130_fd_pr__res_generic_m4 w=0.3 l=0.3
X66 a_11462_11348# a_11246_9428# VGND sky130_fd_pr__res_high_po w=0.36 l=7.36
X67 VDPWR LELO_GR02_0.OSCILLATOR_0.PWRUP_N_1V8 LELO_GR02_0.BANDGAP_0.x5.A VDPWR sky130_fd_pr__pfet_01v8 ad=1.4112 pd=6.74 as=0.8352 ps=3.46 w=2.88 l=0.22
X68 LELO_GR02_0.OSCILLATOR_0.x6.XA6.A LELO_GR02_0.OSCILLATOR_0.x6.XA5.A VDPWR VDPWR sky130_fd_pr__pfet_01v8 ad=0.468 pd=2.84 as=0.468 ps=2.84 w=0.9 l=0.16
X69 LELO_GR02_0.OSCILLATOR_0.x5.x9<4>.S LELO_GR02_0.OSCILLATOR_0.x5.x7.G VGND VGND sky130_fd_pr__nfet_01v8 ad=0.528 pd=2.26 as=0.848 ps=4.26 w=1.6 l=0.94
R4 uio_oe<6> JNWTR_TIEL_CV_0.Y sky130_fd_pr__res_generic_m4 w=0.3 l=0.3
X70 VGND LELO_GR02_0.OSCILLATOR_0.PWRUP_N_1V8 LELO_GR02_0.OSCILLATOR_0.x5.x7.G VGND sky130_fd_pr__nfet_01v8 ad=1.4112 pd=6.74 as=0.8352 ps=3.46 w=2.88 l=0.22
X71 LELO_GR02_0.OSCILLATOR_0.x5.x11.G LELO_GR02_0.OSCILLATOR_0.V_CTAT LELO_GR02_0.OSCILLATOR_0.x5.x9<4>.S VGND sky130_fd_pr__nfet_01v8 ad=0.528 pd=2.26 as=0.848 ps=4.26 w=1.6 l=0.94
X72 LELO_GR02_0.BANDGAP_0.x2.LELOATR_PCH_12C5F0_7.G LELO_GR02_0.BANDGAP_0.x2.LELOATR_PCH_12C5F0_7.G LELO_GR02_0.BANDGAP_0.x2.x2.P VDPWR sky130_fd_pr__pfet_01v8 ad=1.3728 pd=4.82 as=2.2048 ps=9.38 w=4.16 l=0.94
X73 a_17350_4886# a_17566_2966# VGND sky130_fd_pr__res_high_po w=0.36 l=7.36
X74 LELO_GR02_0.OSCILLATOR_0.x6.D LELO_GR02_0.OSCILLATOR_0.x6.XA7.CN LELO_GR02_0.OSCILLATOR_0.x6.XA7.MP1.S VDPWR sky130_fd_pr__pfet_01v8 ad=0.468 pd=2.84 as=0.288 ps=1.54 w=0.9 l=0.16
X75 VGND VGND LELO_GR02_0.BANDGAP_0.x8.DN sky130_fd_pr__pnp_05v5_W3p40L3p40
**devattr s=462400,2720
X76 LELO_GR02_0.BANDGAP_0.x8.DN a_11246_9428# VGND sky130_fd_pr__res_high_po w=0.36 l=7.36
X77 LELO_GR02_0.OSCILLATOR_0.x6.XA7.MP1.S uo_out<0> LELO_GR02_0.OSCILLATOR_0.x6.XA7.MN0.S VGND sky130_fd_pr__nfet_01v8 ad=0.288 pd=1.54 as=0.288 ps=1.54 w=0.9 l=0.16
R5 uio_oe<0> JNWTR_TIEL_CV_0.Y sky130_fd_pr__res_generic_m4 w=0.3 l=0.3
X78 LELO_GR02_0.BANDGAP_0.x5.A LELO_GR02_0.BANDGAP_0.x5.B LELO_GR02_0.OSCILLATOR_0.V_CTAT VDPWR sky130_fd_pr__pfet_01v8 ad=0.4704 pd=2.9 as=0.2784 ps=1.54 w=0.96 l=0.22
X79 LELO_GR02_0.OSCILLATOR_0.x6.XA6.MN1.S LELO_GR02_0.OSCILLATOR_0.x6.XA6.A VGND VGND sky130_fd_pr__nfet_01v8 ad=0.288 pd=1.54 as=0.468 ps=2.84 w=0.9 l=0.16
X80 VGND LELO_GR02_0.OSCILLATOR_0.PWRUP_N_1V8 LELO_GR02_0.BANDGAP_0.x2.x6.D VGND sky130_fd_pr__nfet_01v8 ad=1.4112 pd=6.74 as=0.8352 ps=3.46 w=2.88 l=0.22
X81 LELO_GR02_0.BANDGAP_0.x5.B LELO_GR02_0.BANDGAP_0.x2.x2<1>.A sky130_fd_pr__cap_mim_m3_1 l=5 w=5
X82 LELO_GR02_0.OSCILLATOR_0.x5.x9<4>.S LELO_GR02_0.OSCILLATOR_0.I_PTAT LELO_GR02_0.OSCILLATOR_0.x5.x9<4>.D VGND sky130_fd_pr__nfet_01v8 ad=0.848 pd=4.26 as=0.528 ps=2.26 w=1.6 l=0.94
X83 LELO_GR02_0.OSCILLATOR_0.x6.D LELO_GR02_0.OSCILLATOR_0.x6.XA7.C LELO_GR02_0.OSCILLATOR_0.x6.XA6.MP1.S VDPWR sky130_fd_pr__pfet_01v8 ad=0.468 pd=2.84 as=0.288 ps=1.54 w=0.9 l=0.16
X84 LELO_GR02_0.OSCILLATOR_0.PWRUP_B_1V8 LELO_GR02_0.OSCILLATOR_0.PWRUP_N_1V8 VDPWR VDPWR sky130_fd_pr__pfet_01v8 ad=0.468 pd=2.84 as=0.468 ps=2.84 w=0.9 l=0.16
X85 uo_out<0> LELO_GR02_0.OSCILLATOR_0.x6.D VGND VGND sky130_fd_pr__nfet_01v8 ad=0.468 pd=2.84 as=0.468 ps=2.84 w=0.9 l=0.16
X86 VGND VGND LELO_GR02_0.BANDGAP_0.x8.DN sky130_fd_pr__pnp_05v5_W3p40L3p40
**devattr s=462400,2720
X87 VGND ui_in<0> sky130_fd_pr__diode_pw2nd_05v5 perim=1.8e+06 area=2.025e+11
X88 LELO_GR02_0.BANDGAP_0.x5.A LELO_GR02_0.OSCILLATOR_0.PWRUP_N_1V8 VDPWR VDPWR sky130_fd_pr__pfet_01v8 ad=0.8352 pd=3.46 as=1.4112 ps=6.74 w=2.88 l=0.22
X89 LELO_GR02_0.OSCILLATOR_0.x5.x9<4>.D LELO_GR02_0.OSCILLATOR_0.I_PTAT LELO_GR02_0.OSCILLATOR_0.x5.x9<4>.S VGND sky130_fd_pr__nfet_01v8 ad=0.528 pd=2.26 as=0.848 ps=4.26 w=1.6 l=0.94
X90 LELO_GR02_0.OSCILLATOR_0.x13<2>.B LELO_GR02_0.OSCILLATOR_0.I_PTAT sky130_fd_pr__cap_mim_m3_1 l=5 w=5
X91 VGND LELO_GR02_0.BANDGAP_0.x2.x6.D LELO_GR02_0.BANDGAP_0.x2.LELOATR_NCH_4C5F0_5.D VGND sky130_fd_pr__nfet_01v8 ad=0.848 pd=4.26 as=0.528 ps=2.26 w=1.6 l=0.94
X92 LELO_GR02_0.BANDGAP_0.x2.x2.P LELO_GR02_0.BANDGAP_0.x2.LELOATR_PCH_12C5F0_7.G LELO_GR02_0.BANDGAP_0.x2.x2<1>.A VDPWR sky130_fd_pr__pfet_01v8 ad=2.2048 pd=9.38 as=1.3728 ps=4.82 w=4.16 l=0.94
X93 LELO_GR02_0.OSCILLATOR_0.x6.XA5.A LELO_GR02_0.OSCILLATOR_0.x6.XA7.CN LELO_GR02_0.OSCILLATOR_0.x6.XA4.MN1.S VGND sky130_fd_pr__nfet_01v8 ad=0.468 pd=2.84 as=0.288 ps=1.54 w=0.9 l=0.16
X94 LELO_GR02_0.BANDGAP_0.x5.B LELO_GR02_0.BANDGAP_0.x2.x2<1>.A sky130_fd_pr__cap_mim_m3_1 l=5 w=5
X95 LELO_GR02_0.OSCILLATOR_0.x5.x11.G LELO_GR02_0.OSCILLATOR_0.V_CTAT LELO_GR02_0.OSCILLATOR_0.x5.x9<4>.S VGND sky130_fd_pr__nfet_01v8 ad=0.528 pd=2.26 as=0.848 ps=4.26 w=1.6 l=0.94
X96 LELO_GR02_0.BANDGAP_0.x2.x2.P LELO_GR02_0.BANDGAP_0.x2.LELOATR_PCH_12C5F0_7.G LELO_GR02_0.BANDGAP_0.x2.LELOATR_PCH_12C5F0_7.G VDPWR sky130_fd_pr__pfet_01v8 ad=2.2048 pd=9.38 as=1.3728 ps=4.82 w=4.16 l=0.94
X97 LELO_GR02_0.OSCILLATOR_0.I_PTAT LELO_GR02_0.OSCILLATOR_0.x6.CK LELO_GR02_0.OSCILLATOR_0.x13<2>.B VGND sky130_fd_pr__nfet_01v8 ad=0.5088 pd=2.98 as=0.3168 ps=1.62 w=0.96 l=0.94
X98 a_19078_4886# a_19294_2966# VGND sky130_fd_pr__res_high_po w=0.36 l=7.36
X99 LELO_GR02_0.OSCILLATOR_0.x6.XA7.MN0.S LELO_GR02_0.OSCILLATOR_0.PWRUP_B_1V8 VGND VGND sky130_fd_pr__nfet_01v8 ad=0.288 pd=1.54 as=0.468 ps=2.84 w=0.9 l=0.16
X100 VGND LELO_GR02_0.BANDGAP_0.x2.x6.D LELO_GR02_0.BANDGAP_0.x2.LELOATR_NCH_4C5F0_5.D VGND sky130_fd_pr__nfet_01v8 ad=0.848 pd=4.26 as=0.528 ps=2.26 w=1.6 l=0.94
X101 LELO_GR02_0.BANDGAP_0.x5.B LELO_GR02_0.BANDGAP_0.x2.x2<1>.A LELO_GR02_0.BANDGAP_0.x2.x2.P VDPWR sky130_fd_pr__pfet_01v8 ad=1.3728 pd=4.82 as=2.2048 ps=9.38 w=4.16 l=0.94
X102 VDPWR VDPWR VDPWR VDPWR sky130_fd_pr__pfet_01v8 ad=0.468 pd=2.84 as=16.0632 ps=86.12 w=0.9 l=0.16
X103 LELO_GR02_0.OSCILLATOR_0.V_CTAT LELO_GR02_0.BANDGAP_0.x5.B LELO_GR02_0.BANDGAP_0.x5.A VDPWR sky130_fd_pr__pfet_01v8 ad=0.2784 pd=1.54 as=0.4704 ps=2.9 w=0.96 l=0.22
X104 LELO_GR02_0.BANDGAP_0.x5.A LELO_GR02_0.BANDGAP_0.x5.B LELO_GR02_0.BANDGAP_0.x4.D VDPWR sky130_fd_pr__pfet_01v8 ad=0.4704 pd=2.9 as=0.2784 ps=1.54 w=0.96 l=0.22
X105 LELO_GR02_0.OSCILLATOR_0.x13<2>.B LELO_GR02_0.OSCILLATOR_0.I_PTAT sky130_fd_pr__cap_mim_m3_1 l=5 w=5
X106 LELO_GR02_0.OSCILLATOR_0.x6.CK LELO_GR02_0.OSCILLATOR_0.x5.x7.G VGND VGND sky130_fd_pr__nfet_01v8 ad=0.528 pd=2.26 as=0.848 ps=4.26 w=1.6 l=0.94
X107 JNWTR_TIEL_CV_0.Y JNWTR_TIEL_CV_0.MP0.G VGND VGND sky130_fd_pr__nfet_01v8 ad=0.468 pd=2.84 as=0.468 ps=2.84 w=0.9 l=0.16
X108 LELO_GR02_0.OSCILLATOR_0.x5.x9<4>.D LELO_GR02_0.OSCILLATOR_0.x5.x11.G LELO_GR02_0.OSCILLATOR_0.x5.x11.S VDPWR sky130_fd_pr__pfet_01v8 ad=0.528 pd=2.26 as=0.848 ps=4.26 w=1.6 l=0.94
X109 a_18646_4886# a_18862_2966# VGND sky130_fd_pr__res_high_po w=0.36 l=7.36
X110 LELO_GR02_0.OSCILLATOR_0.x5.x9<4>.S LELO_GR02_0.OSCILLATOR_0.V_CTAT LELO_GR02_0.OSCILLATOR_0.x5.x11.G VGND sky130_fd_pr__nfet_01v8 ad=0.848 pd=4.26 as=0.528 ps=2.26 w=1.6 l=0.94
X111 LELO_GR02_0.BANDGAP_0.x2.x2.P LELO_GR02_0.BANDGAP_0.x2.x2<1>.A LELO_GR02_0.BANDGAP_0.x5.B VDPWR sky130_fd_pr__pfet_01v8 ad=2.2048 pd=9.38 as=1.3728 ps=4.82 w=4.16 l=0.94
X112 a_12326_11348# a_12542_9428# VGND sky130_fd_pr__res_high_po w=0.36 l=7.36
X113 LELO_GR02_0.BANDGAP_0.x5.B LELO_GR02_0.BANDGAP_0.x2.x2<1>.A sky130_fd_pr__cap_mim_m3_1 l=5 w=5
X114 a_19078_4886# a_18862_2966# VGND sky130_fd_pr__res_high_po w=0.36 l=7.36
X115 LELO_GR02_0.OSCILLATOR_0.x5.x11.S LELO_GR02_0.OSCILLATOR_0.x5.x11.G LELO_GR02_0.OSCILLATOR_0.x5.x11.G VDPWR sky130_fd_pr__pfet_01v8 ad=0.848 pd=4.26 as=0.528 ps=2.26 w=1.6 l=0.94
R6 uio_oe<5> JNWTR_TIEL_CV_0.Y sky130_fd_pr__res_generic_m4 w=0.3 l=0.3
X116 LELO_GR02_0.BANDGAP_0.x5.B LELO_GR02_0.BANDGAP_0.x2.x6.D VGND VGND sky130_fd_pr__nfet_01v8 ad=0.528 pd=2.26 as=0.848 ps=4.26 w=1.6 l=0.94
X117 LELO_GR02_0.BANDGAP_0.x2.x2<1>.A LELO_GR02_0.BANDGAP_0.x2.LELOATR_PCH_12C5F0_7.G LELO_GR02_0.BANDGAP_0.x2.x2.P VDPWR sky130_fd_pr__pfet_01v8 ad=1.3728 pd=4.82 as=2.2048 ps=9.38 w=4.16 l=0.94
X118 VGND LELO_GR02_0.OSCILLATOR_0.PWRUP_N_1V8 LELO_GR02_0.OSCILLATOR_0.x6.CK VGND sky130_fd_pr__nfet_01v8 ad=1.4112 pd=6.74 as=0.8352 ps=3.46 w=2.88 l=0.22
X119 VDPWR VDPWR VDPWR VDPWR sky130_fd_pr__pfet_01v8 ad=0.468 pd=2.84 as=0 ps=0 w=0.9 l=0.16
X120 LELO_GR02_0.OSCILLATOR_0.x5.x11.G LELO_GR02_0.OSCILLATOR_0.V_CTAT LELO_GR02_0.OSCILLATOR_0.x5.x9<4>.S VGND sky130_fd_pr__nfet_01v8 ad=0.528 pd=2.26 as=0.848 ps=4.26 w=1.6 l=0.94
X121 a_18646_4886# a_18430_2966# VGND sky130_fd_pr__res_high_po w=0.36 l=7.36
X122 LELO_GR02_0.BANDGAP_0.x2.x2.P LELO_GR02_0.BANDGAP_0.x2.LELOATR_PCH_12C5F0_7.G LELO_GR02_0.BANDGAP_0.x2.x2<1>.A VDPWR sky130_fd_pr__pfet_01v8 ad=2.2048 pd=9.38 as=1.3728 ps=4.82 w=4.16 l=0.94
X123 VGND LELO_GR02_0.BANDGAP_0.x2.x6.D LELO_GR02_0.BANDGAP_0.x2.x6.D VGND sky130_fd_pr__nfet_01v8 ad=0.848 pd=4.26 as=0.528 ps=2.26 w=1.6 l=0.94
X124 VGND VGND LELO_GR02_0.BANDGAP_0.x8.DN sky130_fd_pr__pnp_05v5_W3p40L3p40
**devattr s=462400,2720
X125 LELO_GR02_0.OSCILLATOR_0.x5.x9<4>.D LELO_GR02_0.OSCILLATOR_0.I_PTAT LELO_GR02_0.OSCILLATOR_0.x5.x9<4>.S VGND sky130_fd_pr__nfet_01v8 ad=0.528 pd=2.26 as=0.848 ps=4.26 w=1.6 l=0.94
X126 LELO_GR02_0.BANDGAP_0.x2.x2.P LELO_GR02_0.BANDGAP_0.x2.LELOATR_PCH_12C5F0_7.G LELO_GR02_0.BANDGAP_0.x2.LELOATR_PCH_12C5F0_7.G VDPWR sky130_fd_pr__pfet_01v8 ad=2.2048 pd=9.38 as=1.3728 ps=4.82 w=4.16 l=0.94
X127 LELO_GR02_0.BANDGAP_0.x2.LELOATR_PCH_12C5F0_7.G LELO_GR02_0.BANDGAP_0.x2.LELOATR_PCH_12C5F0_7.G LELO_GR02_0.BANDGAP_0.x2.x2.P VDPWR sky130_fd_pr__pfet_01v8 ad=1.3728 pd=4.82 as=2.2048 ps=9.38 w=4.16 l=0.94
X128 a_12326_11348# a_12110_9428# VGND sky130_fd_pr__res_high_po w=0.36 l=7.36
X129 LELO_GR02_0.BANDGAP_0.x5.B LELO_GR02_0.BANDGAP_0.x2.x6.D VGND VGND sky130_fd_pr__nfet_01v8 ad=0.528 pd=2.26 as=0.848 ps=4.26 w=1.6 l=0.94
X130 LELO_GR02_0.OSCILLATOR_0.x6.XA3.MP1.S LELO_GR02_0.OSCILLATOR_0.x6.D VDPWR VDPWR sky130_fd_pr__pfet_01v8 ad=0.288 pd=1.54 as=0.468 ps=2.84 w=0.9 l=0.16
X131 LELO_GR02_0.OSCILLATOR_0.x13<2>.B LELO_GR02_0.OSCILLATOR_0.I_PTAT sky130_fd_pr__cap_mim_m3_1 l=5 w=5
X132 LELO_GR02_0.OSCILLATOR_0.x5.x7.G a_20158_2966# VGND sky130_fd_pr__res_high_po w=0.36 l=7.36
X133 a_17350_4886# a_17134_2966# VGND sky130_fd_pr__res_high_po w=0.36 l=7.36
X134 LELO_GR02_0.OSCILLATOR_0.x6.CK LELO_GR02_0.OSCILLATOR_0.PWRUP_N_1V8 VGND VGND sky130_fd_pr__nfet_01v8 ad=0.8352 pd=3.46 as=1.4112 ps=6.74 w=2.88 l=0.22
X135 LELO_GR02_0.OSCILLATOR_0.x6.XA1.MN1.S LELO_GR02_0.OSCILLATOR_0.x6.CK VGND VGND sky130_fd_pr__nfet_01v8 ad=0.288 pd=1.54 as=0.468 ps=2.84 w=0.9 l=0.16
X136 LELO_GR02_0.OSCILLATOR_0.PWRUP_N_1V8 ui_in<0> VGND VGND sky130_fd_pr__nfet_01v8 ad=0.468 pd=2.84 as=0.468 ps=2.84 w=0.9 l=0.16
X137 LELO_GR02_0.BANDGAP_0.x5.B LELO_GR02_0.BANDGAP_0.x2.x2<1>.A LELO_GR02_0.BANDGAP_0.x2.x2.P VDPWR sky130_fd_pr__pfet_01v8 ad=1.3728 pd=4.82 as=2.2048 ps=9.38 w=4.16 l=0.94
X138 LELO_GR02_0.BANDGAP_0.x2.LELOATR_NCH_4C5F0_5.D LELO_GR02_0.BANDGAP_0.x4.D LELO_GR02_0.BANDGAP_0.x2.x2<1>.A VGND sky130_fd_pr__nfet_01v8 ad=0.848 pd=4.26 as=0.528 ps=2.26 w=1.6 l=0.94
X139 VDPWR LELO_GR02_0.OSCILLATOR_0.PWRUP_B_1V8 LELO_GR02_0.OSCILLATOR_0.x6.XA7.C VDPWR sky130_fd_pr__pfet_01v8 ad=0.468 pd=2.84 as=0.288 ps=1.54 w=0.9 l=0.16
X140 VGND LELO_GR02_0.BANDGAP_0.x2.x6.D LELO_GR02_0.BANDGAP_0.x2.x6.D VGND sky130_fd_pr__nfet_01v8 ad=0.848 pd=4.26 as=0.528 ps=2.26 w=1.6 l=0.94
X141 LELO_GR02_0.OSCILLATOR_0.x5.x9<4>.S LELO_GR02_0.OSCILLATOR_0.I_PTAT LELO_GR02_0.OSCILLATOR_0.x5.x9<4>.D VGND sky130_fd_pr__nfet_01v8 ad=0.848 pd=4.26 as=0.528 ps=2.26 w=1.6 l=0.94
X142 LELO_GR02_0.OSCILLATOR_0.x13<2>.B LELO_GR02_0.OSCILLATOR_0.I_PTAT sky130_fd_pr__cap_mim_m3_1 l=5 w=5
X143 VGND VGND LELO_GR02_0.BANDGAP_0.x8.DN sky130_fd_pr__pnp_05v5_W3p40L3p40
**devattr s=462400,2720
X144 LELO_GR02_0.OSCILLATOR_0.x5.x7.G LELO_GR02_0.OSCILLATOR_0.PWRUP_N_1V8 VGND VGND sky130_fd_pr__nfet_01v8 ad=0.8352 pd=3.46 as=1.4112 ps=6.74 w=2.88 l=0.22
X145 LELO_GR02_0.OSCILLATOR_0.x5.x9<4>.S LELO_GR02_0.OSCILLATOR_0.V_CTAT LELO_GR02_0.OSCILLATOR_0.x5.x11.G VGND sky130_fd_pr__nfet_01v8 ad=0.848 pd=4.26 as=0.528 ps=2.26 w=1.6 l=0.94
X146 a_19942_4886# a_20158_2966# VGND sky130_fd_pr__res_high_po w=0.36 l=7.36
X147 VGND VGND LELO_GR02_0.BANDGAP_0.x8.DN sky130_fd_pr__pnp_05v5_W3p40L3p40
**devattr s=462400,2720
X148 LELO_GR02_0.OSCILLATOR_0.x5.x11.S a_17134_2966# VGND sky130_fd_pr__res_high_po w=0.36 l=7.36
X149 VGND LELO_GR02_0.OSCILLATOR_0.x5.x7.G LELO_GR02_0.OSCILLATOR_0.x5.x7.G VGND sky130_fd_pr__nfet_01v8 ad=0.848 pd=4.26 as=0.528 ps=2.26 w=1.6 l=0.94
X150 LELO_GR02_0.OSCILLATOR_0.x5.x9<4>.D LELO_GR02_0.OSCILLATOR_0.I_PTAT LELO_GR02_0.OSCILLATOR_0.x5.x9<4>.S VGND sky130_fd_pr__nfet_01v8 ad=0.528 pd=2.26 as=0.848 ps=4.26 w=1.6 l=0.94
X151 LELO_GR02_0.OSCILLATOR_0.x6.XA7.MP1.S uo_out<0> VDPWR VDPWR sky130_fd_pr__pfet_01v8 ad=0.288 pd=1.54 as=0.288 ps=1.54 w=0.9 l=0.16
X152 LELO_GR02_0.BANDGAP_0.x2.x2.P LELO_GR02_0.BANDGAP_0.x2.LELOATR_PCH_12C5F0_7.G LELO_GR02_0.BANDGAP_0.x2.x2<1>.A VDPWR sky130_fd_pr__pfet_01v8 ad=2.2048 pd=9.38 as=1.3728 ps=4.82 w=4.16 l=0.94
X153 LELO_GR02_0.OSCILLATOR_0.x13<2>.B LELO_GR02_0.OSCILLATOR_0.I_PTAT sky130_fd_pr__cap_mim_m3_1 l=5 w=5
X154 LELO_GR02_0.OSCILLATOR_0.x6.XA6.MP1.S LELO_GR02_0.OSCILLATOR_0.x6.XA6.A VDPWR VDPWR sky130_fd_pr__pfet_01v8 ad=0.288 pd=1.54 as=0.468 ps=2.84 w=0.9 l=0.16
X155 VGND LELO_GR02_0.OSCILLATOR_0.PWRUP_N_1V8 LELO_GR02_0.OSCILLATOR_0.x5.x7.G VGND sky130_fd_pr__nfet_01v8 ad=1.4112 pd=6.74 as=0.8352 ps=3.46 w=2.88 l=0.22
X156 a_6491_5710# a_6275_3790# VGND sky130_fd_pr__res_high_po w=0.36 l=7.36
X157 VGND LELO_GR02_0.OSCILLATOR_0.x5.x7.G LELO_GR02_0.OSCILLATOR_0.x5.x9<4>.S VGND sky130_fd_pr__nfet_01v8 ad=0.848 pd=4.26 as=0.528 ps=2.26 w=1.6 l=0.94
X158 LELO_GR02_0.BANDGAP_0.x2.x6.D LELO_GR02_0.OSCILLATOR_0.PWRUP_N_1V8 VGND VGND sky130_fd_pr__nfet_01v8 ad=0.8352 pd=3.46 as=1.4112 ps=6.74 w=2.88 l=0.22
R7 uio_oe<4> JNWTR_TIEL_CV_0.Y sky130_fd_pr__res_generic_m4 w=0.3 l=0.3
X159 LELO_GR02_0.OSCILLATOR_0.x6.XA7.CN LELO_GR02_0.OSCILLATOR_0.x6.XA7.C VGND VGND sky130_fd_pr__nfet_01v8 ad=0.468 pd=2.84 as=0.468 ps=2.84 w=0.9 l=0.16
X160 LELO_GR02_0.BANDGAP_0.x2.x2.P LELO_GR02_0.BANDGAP_0.x2.LELOATR_PCH_12C5F0_7.G LELO_GR02_0.BANDGAP_0.x2.LELOATR_PCH_12C5F0_7.G VDPWR sky130_fd_pr__pfet_01v8 ad=2.2048 pd=9.38 as=1.3728 ps=4.82 w=4.16 l=0.94
X161 LELO_GR02_0.BANDGAP_0.x2.LELOATR_PCH_12C5F0_7.G LELO_GR02_0.OSCILLATOR_0.V_CTAT LELO_GR02_0.BANDGAP_0.x2.LELOATR_NCH_4C5F0_5.D VGND sky130_fd_pr__nfet_01v8 ad=0.528 pd=2.26 as=0.848 ps=4.26 w=1.6 l=0.94
X162 LELO_GR02_0.OSCILLATOR_0.x5.x11.S LELO_GR02_0.OSCILLATOR_0.x5.x9<4>.D LELO_GR02_0.OSCILLATOR_0.x6.CK VDPWR sky130_fd_pr__pfet_01v8_lvt ad=0.848 pd=4.26 as=0.528 ps=2.26 w=1.6 l=0.94
X163 JNWTR_TIEL_CV_0.MP0.G JNWTR_TIEL_CV_0.MP0.G VDPWR VDPWR sky130_fd_pr__pfet_01v8 ad=0.468 pd=2.84 as=0.468 ps=2.84 w=0.9 l=0.16
X164 LELO_GR02_0.BANDGAP_0.x5.B LELO_GR02_0.BANDGAP_0.x2.x2<1>.A LELO_GR02_0.BANDGAP_0.x2.x2.P VDPWR sky130_fd_pr__pfet_01v8 ad=1.3728 pd=4.82 as=2.2048 ps=9.38 w=4.16 l=0.94
X165 uo_out<0> LELO_GR02_0.OSCILLATOR_0.x6.D VDPWR VDPWR sky130_fd_pr__pfet_01v8 ad=0.468 pd=2.84 as=0.468 ps=2.84 w=0.9 l=0.16
X166 a_19942_4886# a_19726_2966# VGND sky130_fd_pr__res_high_po w=0.36 l=7.36
X167 VGND LELO_GR02_0.OSCILLATOR_0.PWRUP_N_1V8 LELO_GR02_0.OSCILLATOR_0.x6.CK VGND sky130_fd_pr__nfet_01v8 ad=1.4112 pd=6.74 as=0.8352 ps=3.46 w=2.88 l=0.22
X168 VGND VGND LELO_GR02_0.BANDGAP_0.x8.DN sky130_fd_pr__pnp_05v5_W3p40L3p40
**devattr s=462400,2720
X169 LELO_GR02_0.OSCILLATOR_0.x5.x9<4>.S LELO_GR02_0.OSCILLATOR_0.I_PTAT LELO_GR02_0.OSCILLATOR_0.x5.x9<4>.D VGND sky130_fd_pr__nfet_01v8 ad=0.848 pd=4.26 as=0.528 ps=2.26 w=1.6 l=0.94
X170 LELO_GR02_0.BANDGAP_0.x5.B LELO_GR02_0.BANDGAP_0.x2.x2<1>.A sky130_fd_pr__cap_mim_m3_1 l=5 w=5
X171 a_6059_5710# a_6275_3790# VGND sky130_fd_pr__res_high_po w=0.36 l=7.36
X172 LELO_GR02_0.OSCILLATOR_0.x6.XA5.A LELO_GR02_0.OSCILLATOR_0.x6.XA7.C LELO_GR02_0.OSCILLATOR_0.x6.XA4.MP1.S VDPWR sky130_fd_pr__pfet_01v8 ad=0.468 pd=2.84 as=0.288 ps=1.54 w=0.9 l=0.16
X173 LELO_GR02_0.OSCILLATOR_0.x6.XA5.A LELO_GR02_0.OSCILLATOR_0.x6.XA7.C LELO_GR02_0.OSCILLATOR_0.x6.XA3.MN1.S VGND sky130_fd_pr__nfet_01v8 ad=0.468 pd=2.84 as=0.288 ps=1.54 w=0.9 l=0.16
X174 LELO_GR02_0.OSCILLATOR_0.x6.XA4.MN1.S LELO_GR02_0.OSCILLATOR_0.x6.XA6.A VGND VGND sky130_fd_pr__nfet_01v8 ad=0.288 pd=1.54 as=0.468 ps=2.84 w=0.9 l=0.16
X175 a_19510_4886# a_19726_2966# VGND sky130_fd_pr__res_high_po w=0.36 l=7.36
X176 LELO_GR02_0.BANDGAP_0.x4.D LELO_GR02_0.BANDGAP_0.x5.B LELO_GR02_0.BANDGAP_0.x5.A VDPWR sky130_fd_pr__pfet_01v8 ad=0.2784 pd=1.54 as=0.4704 ps=2.9 w=0.96 l=0.22
X177 LELO_GR02_0.OSCILLATOR_0.x5.x9<4>.S LELO_GR02_0.OSCILLATOR_0.V_CTAT LELO_GR02_0.OSCILLATOR_0.x5.x11.G VGND sky130_fd_pr__nfet_01v8 ad=0.848 pd=4.26 as=0.528 ps=2.26 w=1.6 l=0.94
X178 a_5627_5710# a_5843_3790# VGND sky130_fd_pr__res_high_po w=0.36 l=7.36
X179 VDPWR LELO_GR02_0.OSCILLATOR_0.PWRUP_B_1V8 LELO_GR02_0.OSCILLATOR_0.x6.XA7.MP1.S VDPWR sky130_fd_pr__pfet_01v8 ad=0.288 pd=1.54 as=0.468 ps=2.84 w=0.9 l=0.16
X180 LELO_GR02_0.BANDGAP_0.x5.B LELO_GR02_0.BANDGAP_0.x2.x2<1>.A sky130_fd_pr__cap_mim_m3_1 l=5 w=5
X181 VGND VGND LELO_GR02_0.BANDGAP_0.x8.DN sky130_fd_pr__pnp_05v5_W3p40L3p40
**devattr s=462400,2720
X182 VGND LELO_GR02_0.OSCILLATOR_0.PWRUP_N_1V8 LELO_GR02_0.BANDGAP_0.x5.B VGND sky130_fd_pr__nfet_01v8 ad=1.4112 pd=6.74 as=0.8352 ps=3.46 w=2.88 l=0.22
X183 a_6059_5710# a_5843_3790# VGND sky130_fd_pr__res_high_po w=0.36 l=7.36
X184 VDPWR LELO_GR02_0.OSCILLATOR_0.PWRUP_N_1V8 LELO_GR02_0.OSCILLATOR_0.x5.x11.S VDPWR sky130_fd_pr__pfet_01v8 ad=1.4112 pd=6.74 as=0.8352 ps=3.46 w=2.88 l=0.22
X185 LELO_GR02_0.OSCILLATOR_0.x5.x11.G LELO_GR02_0.OSCILLATOR_0.V_CTAT LELO_GR02_0.OSCILLATOR_0.x5.x9<4>.S VGND sky130_fd_pr__nfet_01v8 ad=0.528 pd=2.26 as=0.848 ps=4.26 w=1.6 l=0.94
X186 LELO_GR02_0.OSCILLATOR_0.x13<2>.B LELO_GR02_0.OSCILLATOR_0.I_PTAT sky130_fd_pr__cap_mim_m3_1 l=5 w=5
X187 a_11894_11348# a_11678_9428# VGND sky130_fd_pr__res_high_po w=0.36 l=7.36
X188 LELO_GR02_0.OSCILLATOR_0.x6.XA6.A LELO_GR02_0.OSCILLATOR_0.x6.XA5.A VGND VGND sky130_fd_pr__nfet_01v8 ad=0.468 pd=2.84 as=0.468 ps=2.84 w=0.9 l=0.16
X189 a_18214_4886# a_18430_2966# VGND sky130_fd_pr__res_high_po w=0.36 l=7.36
X190 LELO_GR02_0.BANDGAP_0.x5.A LELO_GR02_0.BANDGAP_0.x5.B LELO_GR02_0.OSCILLATOR_0.I_PTAT VDPWR sky130_fd_pr__pfet_01v8 ad=0.4704 pd=2.9 as=0.2784 ps=1.54 w=0.96 l=0.22
X191 a_5627_5710# a_5411_3790# VGND sky130_fd_pr__res_high_po w=0.36 l=7.36
X192 a_11894_11348# a_12110_9428# VGND sky130_fd_pr__res_high_po w=0.36 l=7.36
X193 VDPWR LELO_GR02_0.OSCILLATOR_0.PWRUP_N_1V8 LELO_GR02_0.BANDGAP_0.x2.x2.P VDPWR sky130_fd_pr__pfet_01v8 ad=1.4112 pd=6.74 as=0.8352 ps=3.46 w=2.88 l=0.22
X194 a_17782_4886# a_17998_2966# VGND sky130_fd_pr__res_high_po w=0.36 l=7.36
X195 LELO_GR02_0.OSCILLATOR_0.x6.D LELO_GR02_0.OSCILLATOR_0.x6.XA7.C LELO_GR02_0.OSCILLATOR_0.x6.XA7.MP1.S VGND sky130_fd_pr__nfet_01v8 ad=0.468 pd=2.84 as=0.288 ps=1.54 w=0.9 l=0.16
X196 LELO_GR02_0.BANDGAP_0.x2.x2.P LELO_GR02_0.BANDGAP_0.x2.x2<1>.A LELO_GR02_0.BANDGAP_0.x5.B VDPWR sky130_fd_pr__pfet_01v8 ad=2.2048 pd=9.38 as=1.3728 ps=4.82 w=4.16 l=0.94
X197 a_11462_11348# a_11678_9428# VGND sky130_fd_pr__res_high_po w=0.36 l=7.36
X198 VGND VGND LELO_GR02_0.OSCILLATOR_0.V_CTAT sky130_fd_pr__pnp_05v5_W3p40L3p40
**devattr s=462400,2720
X199 a_18214_4886# a_17998_2966# VGND sky130_fd_pr__res_high_po w=0.36 l=7.36
X200 LELO_GR02_0.OSCILLATOR_0.x6.CK LELO_GR02_0.OSCILLATOR_0.PWRUP_N_1V8 VGND VGND sky130_fd_pr__nfet_01v8 ad=0.8352 pd=3.46 as=1.4112 ps=6.74 w=2.88 l=0.22
X201 LELO_GR02_0.BANDGAP_0.x2.LELOATR_NCH_4C5F0_5.D LELO_GR02_0.BANDGAP_0.x2.x6.D VGND VGND sky130_fd_pr__nfet_01v8 ad=0.528 pd=2.26 as=0.848 ps=4.26 w=1.6 l=0.94
X202 VGND LELO_GR02_0.OSCILLATOR_0.x5.x7.G LELO_GR02_0.OSCILLATOR_0.x6.CK VGND sky130_fd_pr__nfet_01v8 ad=0.848 pd=4.26 as=0.528 ps=2.26 w=1.6 l=0.94
X203 LELO_GR02_0.BANDGAP_0.x2.x2<1>.A LELO_GR02_0.BANDGAP_0.x2.LELOATR_PCH_12C5F0_7.G LELO_GR02_0.BANDGAP_0.x2.x2.P VDPWR sky130_fd_pr__pfet_01v8 ad=1.3728 pd=4.82 as=2.2048 ps=9.38 w=4.16 l=0.94
X204 LELO_GR02_0.OSCILLATOR_0.x5.x9<4>.S LELO_GR02_0.OSCILLATOR_0.I_PTAT LELO_GR02_0.OSCILLATOR_0.x5.x9<4>.D VGND sky130_fd_pr__nfet_01v8 ad=0.848 pd=4.26 as=0.528 ps=2.26 w=1.6 l=0.94
C0 JNWTR_TIEL_CV_0.Y JNWTR_TIEL_CV_0.MP0.G 0.01589f
C1 JNWTR_TIEL_CV_0.MP0.G VDPWR 0.57472f
C2 JNWTR_TIEL_CV_0.MP0.G VGND 0.53358f
C3 JNWTR_TIEL_CV_0.MP0.G a_28156_21150# 0.05912f
C4 a_28156_21470# JNWTR_TIEL_CV_0.MP0.G 0.06129f
C5 JNWTR_TIEL_CV_0.MP0.G a_28996_21150# 0.06636f
C6 a_28996_21470# JNWTR_TIEL_CV_0.MP0.G 0.08348f
C7 JNWTR_TIEL_CV_0.Y VDPWR 0.03806f
C8 JNWTR_TIEL_CV_0.Y VGND 7.62019f
C9 a_28156_21470# JNWTR_TIEL_CV_0.Y 0.03751f
C10 JNWTR_TIEL_CV_0.Y ui_in<0> 2.06747f
C11 JNWTR_TIEL_CV_0.Y uo_out<0> 1.20523f
C12 LELO_GR02_0.BANDGAP_0.x2.LELOATR_PCH_12C5F0_7.G LELO_GR02_0.BANDGAP_0.x2.LELOATR_NCH_4C5F0_5.D 0.2996f
C13 LELO_GR02_0.BANDGAP_0.x2.x2.P LELO_GR02_0.BANDGAP_0.x2.LELOATR_NCH_4C5F0_5.D 0.80444f
C14 LELO_GR02_0.BANDGAP_0.x2.x2<1>.A LELO_GR02_0.BANDGAP_0.x2.LELOATR_NCH_4C5F0_5.D 0.42839f
C15 LELO_GR02_0.BANDGAP_0.x2.LELOATR_NCH_4C5F0_5.D LELO_GR02_0.BANDGAP_0.x2.x6.D 0.85724f
C16 LELO_GR02_0.BANDGAP_0.x4.D LELO_GR02_0.BANDGAP_0.x2.LELOATR_NCH_4C5F0_5.D 0.64175f
C17 LELO_GR02_0.BANDGAP_0.x5.B LELO_GR02_0.BANDGAP_0.x2.LELOATR_NCH_4C5F0_5.D 0.26526f
C18 LELO_GR02_0.OSCILLATOR_0.PWRUP_N_1V8 LELO_GR02_0.BANDGAP_0.x2.LELOATR_NCH_4C5F0_5.D 0.06978f
C19 LELO_GR02_0.OSCILLATOR_0.V_CTAT LELO_GR02_0.BANDGAP_0.x2.LELOATR_NCH_4C5F0_5.D 0.82015f
C20 LELO_GR02_0.BANDGAP_0.x2.LELOATR_NCH_4C5F0_5.D VDPWR 0.03216f
C21 LELO_GR02_0.BANDGAP_0.x2.LELOATR_NCH_4C5F0_5.D VGND 2.93206f
C22 LELO_GR02_0.BANDGAP_0.x2.LELOATR_NCH_4C5F0_5.D a_5141_9060# 0.05306f
C23 a_5141_9860# LELO_GR02_0.BANDGAP_0.x2.LELOATR_NCH_4C5F0_5.D 0.05659f
C24 LELO_GR02_0.BANDGAP_0.x2.LELOATR_NCH_4C5F0_5.D a_5773_7035# 0.013f
C25 LELO_GR02_0.BANDGAP_0.x2.LELOATR_NCH_4C5F0_5.D a_5773_7835# 0.03089f
C26 LELO_GR02_0.BANDGAP_0.x2.LELOATR_NCH_4C5F0_5.D a_5773_7970# 0.0311f
C27 LELO_GR02_0.BANDGAP_0.x2.LELOATR_NCH_4C5F0_5.D a_5773_8770# 0.04329f
C28 LELO_GR02_0.BANDGAP_0.x2.LELOATR_NCH_4C5F0_5.D a_6392_9060# 0.05458f
C29 LELO_GR02_0.BANDGAP_0.x2.LELOATR_NCH_4C5F0_5.D a_6392_9860# 0.05643f
C30 LELO_GR02_0.BANDGAP_0.x2.LELOATR_NCH_4C5F0_5.D m1_5524_9447# 0.20586f
C31 LELO_GR02_0.BANDGAP_0.x2.x2.P LELO_GR02_0.BANDGAP_0.x2.LELOATR_PCH_12C5F0_7.G 9.7746f
C32 LELO_GR02_0.BANDGAP_0.x2.LELOATR_PCH_12C5F0_7.G LELO_GR02_0.BANDGAP_0.x2.x2<1>.A 2.42363f
C33 LELO_GR02_0.BANDGAP_0.x2.LELOATR_PCH_12C5F0_7.G LELO_GR02_0.BANDGAP_0.x2.x6.D 0.0508f
C34 LELO_GR02_0.BANDGAP_0.x2.LELOATR_PCH_12C5F0_7.G LELO_GR02_0.BANDGAP_0.x4.D 0.30988f
C35 LELO_GR02_0.BANDGAP_0.x2.LELOATR_PCH_12C5F0_7.G LELO_GR02_0.BANDGAP_0.x5.B 0.05496f
C36 LELO_GR02_0.OSCILLATOR_0.PWRUP_N_1V8 LELO_GR02_0.BANDGAP_0.x2.LELOATR_PCH_12C5F0_7.G 1.03199f
C37 LELO_GR02_0.BANDGAP_0.x2.LELOATR_PCH_12C5F0_7.G LELO_GR02_0.OSCILLATOR_0.V_CTAT 0.36063f
C38 LELO_GR02_0.BANDGAP_0.x2.LELOATR_PCH_12C5F0_7.G VDPWR 15.2981f
C39 LELO_GR02_0.BANDGAP_0.x2.LELOATR_PCH_12C5F0_7.G VGND 3.08162f
C40 LELO_GR02_0.BANDGAP_0.x2.LELOATR_PCH_12C5F0_7.G a_3743_10332# 0.11528f
C41 LELO_GR02_0.BANDGAP_0.x2.LELOATR_PCH_12C5F0_7.G a_3743_11132# 0.11352f
C42 LELO_GR02_0.BANDGAP_0.x2.LELOATR_PCH_12C5F0_7.G a_3743_11266# 0.11344f
C43 LELO_GR02_0.BANDGAP_0.x2.LELOATR_PCH_12C5F0_7.G a_3743_12066# 0.11317f
C44 LELO_GR02_0.BANDGAP_0.x2.LELOATR_PCH_12C5F0_7.G a_3743_12200# 0.11317f
C45 LELO_GR02_0.BANDGAP_0.x2.LELOATR_PCH_12C5F0_7.G a_3743_13000# 0.11473f
C46 LELO_GR02_0.BANDGAP_0.x2.LELOATR_PCH_12C5F0_7.G a_3744_13136# 0.11503f
C47 a_3744_13936# LELO_GR02_0.BANDGAP_0.x2.LELOATR_PCH_12C5F0_7.G 0.10297f
C48 LELO_GR02_0.BANDGAP_0.x2.LELOATR_PCH_12C5F0_7.G a_5141_9060# 0.01028f
C49 LELO_GR02_0.BANDGAP_0.x2.LELOATR_PCH_12C5F0_7.G a_5141_9860# 0.0386f
C50 LELO_GR02_0.BANDGAP_0.x2.LELOATR_PCH_12C5F0_7.G a_5506_10332# 0.07092f
C51 LELO_GR02_0.BANDGAP_0.x2.LELOATR_PCH_12C5F0_7.G a_5506_11132# 0.07582f
C52 LELO_GR02_0.BANDGAP_0.x2.LELOATR_PCH_12C5F0_7.G a_5506_11266# 0.07582f
C53 LELO_GR02_0.BANDGAP_0.x2.LELOATR_PCH_12C5F0_7.G a_5506_12066# 0.07582f
C54 LELO_GR02_0.BANDGAP_0.x2.LELOATR_PCH_12C5F0_7.G a_5506_12200# 0.07582f
C55 LELO_GR02_0.BANDGAP_0.x2.LELOATR_PCH_12C5F0_7.G a_5506_13000# 0.07583f
C56 LELO_GR02_0.BANDGAP_0.x2.LELOATR_PCH_12C5F0_7.G a_5507_13136# 0.07575f
C57 LELO_GR02_0.BANDGAP_0.x2.LELOATR_PCH_12C5F0_7.G a_5507_13936# 0.07439f
C58 LELO_GR02_0.BANDGAP_0.x2.LELOATR_PCH_12C5F0_7.G m1_5524_9447# 0.21849f
C59 LELO_GR02_0.BANDGAP_0.x2.x2.P LELO_GR02_0.BANDGAP_0.x2.x2<1>.A 6.01045f
C60 LELO_GR02_0.BANDGAP_0.x2.x2.P LELO_GR02_0.BANDGAP_0.x2.x6.D 0.54889f
C61 LELO_GR02_0.BANDGAP_0.x2.x2.P LELO_GR02_0.BANDGAP_0.x4.D 1.39722f
C62 LELO_GR02_0.BANDGAP_0.x2.x2.P LELO_GR02_0.BANDGAP_0.x5.A 0.0108f
C63 LELO_GR02_0.BANDGAP_0.x2.x2.P LELO_GR02_0.BANDGAP_0.x5.B 2.25925f
C64 LELO_GR02_0.OSCILLATOR_0.PWRUP_N_1V8 LELO_GR02_0.BANDGAP_0.x2.x2.P 2.64007f
C65 LELO_GR02_0.BANDGAP_0.x2.x2.P LELO_GR02_0.OSCILLATOR_0.V_CTAT 0.25938f
C66 LELO_GR02_0.BANDGAP_0.x2.x2.P VDPWR 7.97912f
C67 LELO_GR02_0.BANDGAP_0.x2.x2.P VGND 7.01825f
C68 LELO_GR02_0.BANDGAP_0.x2.x2.P a_3743_10332# 0.11167f
C69 LELO_GR02_0.BANDGAP_0.x2.x2.P a_3743_11132# 0.14807f
C70 LELO_GR02_0.BANDGAP_0.x2.x2.P a_3743_11266# 0.1481f
C71 LELO_GR02_0.BANDGAP_0.x2.x2.P a_3743_12066# 0.1481f
C72 LELO_GR02_0.BANDGAP_0.x2.x2.P a_3743_12200# 0.1481f
C73 LELO_GR02_0.BANDGAP_0.x2.x2.P a_3743_13000# 0.14787f
C74 LELO_GR02_0.BANDGAP_0.x2.x2.P a_3744_13136# 0.14782f
C75 LELO_GR02_0.BANDGAP_0.x2.x2.P a_3744_13936# 0.1481f
C76 LELO_GR02_0.BANDGAP_0.x2.x2.P a_5506_10332# 0.14541f
C77 LELO_GR02_0.BANDGAP_0.x2.x2.P a_5506_11132# 0.16162f
C78 LELO_GR02_0.BANDGAP_0.x2.x2.P a_5506_11266# 0.16162f
C79 LELO_GR02_0.BANDGAP_0.x2.x2.P a_5506_12066# 0.16021f
C80 LELO_GR02_0.BANDGAP_0.x2.x2.P a_5506_12200# 0.16014f
C81 LELO_GR02_0.BANDGAP_0.x2.x2.P a_5506_13000# 0.1628f
C82 LELO_GR02_0.BANDGAP_0.x2.x2.P a_5507_13136# 0.16282f
C83 LELO_GR02_0.BANDGAP_0.x2.x2.P a_5507_13936# 0.168f
C84 LELO_GR02_0.BANDGAP_0.x2.x2.P a_5664_14810# 0.12211f
C85 LELO_GR02_0.BANDGAP_0.x2.x2.P a_5664_14970# 0.05193f
C86 a_5664_15450# LELO_GR02_0.BANDGAP_0.x2.x2.P 0.0396f
C87 a_5664_15610# LELO_GR02_0.BANDGAP_0.x2.x2.P 0.01142f
C88 LELO_GR02_0.BANDGAP_0.x2.x2.P a_5773_7035# 0.01743f
C89 LELO_GR02_0.BANDGAP_0.x2.x2.P a_5773_8770# 0.01252f
C90 LELO_GR02_0.BANDGAP_0.x2.x2.P a_6059_5710# 0.02579f
C91 LELO_GR02_0.BANDGAP_0.x2.x2.P a_6491_5710# 0.28135f
C92 LELO_GR02_0.BANDGAP_0.x2.x2.P a_7023_7034# 0.01397f
C93 LELO_GR02_0.BANDGAP_0.x2.x2.P a_7139_3790# 0.0211f
C94 LELO_GR02_0.BANDGAP_0.x2.x2.P a_7268_10332# 0.11128f
C95 LELO_GR02_0.BANDGAP_0.x2.x2.P a_7268_11132# 0.14876f
C96 LELO_GR02_0.BANDGAP_0.x2.x2.P a_7268_11266# 0.14879f
C97 LELO_GR02_0.BANDGAP_0.x2.x2.P a_7268_12066# 0.14813f
C98 LELO_GR02_0.BANDGAP_0.x2.x2.P a_7268_12200# 0.1481f
C99 LELO_GR02_0.BANDGAP_0.x2.x2.P a_7268_13000# 0.14855f
C100 LELO_GR02_0.BANDGAP_0.x2.x2.P a_7269_13136# 0.14849f
C101 LELO_GR02_0.BANDGAP_0.x2.x2.P a_7269_13936# 0.14872f
C102 LELO_GR02_0.BANDGAP_0.x2.x2.P a_8748_14798# 0.02741f
C103 LELO_GR02_0.BANDGAP_0.x2.x2<1>.A LELO_GR02_0.BANDGAP_0.x2.x6.D 0.0832f
C104 LELO_GR02_0.BANDGAP_0.x2.x2<1>.A LELO_GR02_0.BANDGAP_0.x4.D 2.09873f
C105 LELO_GR02_0.BANDGAP_0.x5.A LELO_GR02_0.BANDGAP_0.x2.x2<1>.A 0.03399f
C106 LELO_GR02_0.BANDGAP_0.x2.x2<1>.A LELO_GR02_0.BANDGAP_0.x5.B 25.7049f
C107 LELO_GR02_0.BANDGAP_0.x2.x2<1>.A LELO_GR02_0.BANDGAP_0.x8.DN 2.14959f
C108 LELO_GR02_0.OSCILLATOR_0.PWRUP_N_1V8 LELO_GR02_0.BANDGAP_0.x2.x2<1>.A 0.78489f
C109 LELO_GR02_0.BANDGAP_0.x2.x2<1>.A LELO_GR02_0.OSCILLATOR_0.V_CTAT 0.4253f
C110 LELO_GR02_0.BANDGAP_0.x2.x2<1>.A VDPWR 8.68177f
C111 LELO_GR02_0.BANDGAP_0.x2.x2<1>.A VGND 16.0294f
C112 LELO_GR02_0.BANDGAP_0.x2.x2<1>.A a_3635_9859# 0.01098f
C113 LELO_GR02_0.BANDGAP_0.x2.x2<1>.A a_5195_3790# 0.04575f
C114 LELO_GR02_0.BANDGAP_0.x2.x2<1>.A a_5411_3790# 0.01221f
C115 LELO_GR02_0.BANDGAP_0.x2.x2<1>.A a_5506_10332# 0.04504f
C116 LELO_GR02_0.BANDGAP_0.x2.x2<1>.A a_5506_11132# 0.03256f
C117 LELO_GR02_0.BANDGAP_0.x2.x2<1>.A a_5506_11266# 0.03228f
C118 LELO_GR02_0.BANDGAP_0.x2.x2<1>.A a_5506_12066# 0.02985f
C119 LELO_GR02_0.BANDGAP_0.x2.x2<1>.A a_5506_12200# 0.02981f
C120 LELO_GR02_0.BANDGAP_0.x2.x2<1>.A a_5506_13000# 0.03708f
C121 LELO_GR02_0.BANDGAP_0.x2.x2<1>.A a_5507_13136# 0.03711f
C122 a_5507_13936# LELO_GR02_0.BANDGAP_0.x2.x2<1>.A 0.03399f
C123 LELO_GR02_0.BANDGAP_0.x2.x2<1>.A a_6392_9060# 0.01029f
C124 LELO_GR02_0.BANDGAP_0.x2.x2<1>.A a_6392_9860# 0.05053f
C125 LELO_GR02_0.BANDGAP_0.x2.x2<1>.A a_6707_3790# 0.0123f
C126 LELO_GR02_0.BANDGAP_0.x2.x2<1>.A a_7139_3790# 0.04065f
C127 LELO_GR02_0.BANDGAP_0.x2.x2<1>.A a_7268_10332# 0.09281f
C128 LELO_GR02_0.BANDGAP_0.x2.x2<1>.A a_7268_11132# 0.07831f
C129 LELO_GR02_0.BANDGAP_0.x2.x2<1>.A a_7268_11266# 0.078f
C130 LELO_GR02_0.BANDGAP_0.x2.x2<1>.A a_7268_12066# 0.07582f
C131 LELO_GR02_0.BANDGAP_0.x2.x2<1>.A a_7268_12200# 0.07582f
C132 LELO_GR02_0.BANDGAP_0.x2.x2<1>.A a_7268_13000# 0.07583f
C133 LELO_GR02_0.BANDGAP_0.x2.x2<1>.A a_7269_13136# 0.07575f
C134 LELO_GR02_0.BANDGAP_0.x2.x2<1>.A a_7269_13936# 0.07439f
C135 LELO_GR02_0.BANDGAP_0.x5.B LELO_GR02_0.BANDGAP_0.x2.x6.D 1.01851f
C136 LELO_GR02_0.OSCILLATOR_0.PWRUP_N_1V8 LELO_GR02_0.BANDGAP_0.x2.x6.D 0.29307f
C137 LELO_GR02_0.OSCILLATOR_0.V_CTAT LELO_GR02_0.BANDGAP_0.x2.x6.D 0.0139f
C138 LELO_GR02_0.BANDGAP_0.x2.x6.D VGND 21.8057f
C139 LELO_GR02_0.BANDGAP_0.x2.x6.D a_3635_9059# 0.01881f
C140 LELO_GR02_0.BANDGAP_0.x2.x6.D a_3635_9219# 0.0403f
C141 a_3635_9699# LELO_GR02_0.BANDGAP_0.x2.x6.D 0.03854f
C142 a_3635_9859# LELO_GR02_0.BANDGAP_0.x2.x6.D 0.0106f
C143 LELO_GR02_0.BANDGAP_0.x2.x6.D a_4521_7034# 0.11933f
C144 LELO_GR02_0.BANDGAP_0.x2.x6.D a_4521_7834# 0.10878f
C145 LELO_GR02_0.BANDGAP_0.x2.x6.D a_4521_7969# 0.1087f
C146 LELO_GR02_0.BANDGAP_0.x2.x6.D a_4521_8769# 0.11262f
C147 LELO_GR02_0.BANDGAP_0.x2.x6.D a_5195_3790# 0.02126f
C148 LELO_GR02_0.BANDGAP_0.x2.x6.D a_5627_5710# 0.24398f
C149 LELO_GR02_0.BANDGAP_0.x2.x6.D a_5773_7035# 0.08293f
C150 LELO_GR02_0.BANDGAP_0.x2.x6.D a_5773_7835# 0.07665f
C151 LELO_GR02_0.BANDGAP_0.x2.x6.D a_5773_7970# 0.07647f
C152 LELO_GR02_0.BANDGAP_0.x2.x6.D a_5773_8770# 0.07161f
C153 LELO_GR02_0.BANDGAP_0.x2.x6.D a_6059_5710# 0.01934f
C154 LELO_GR02_0.BANDGAP_0.x2.x6.D a_6491_5710# 0.02283f
C155 LELO_GR02_0.BANDGAP_0.x2.x6.D a_7023_7034# 0.08399f
C156 LELO_GR02_0.BANDGAP_0.x2.x6.D a_7023_7834# 0.07665f
C157 LELO_GR02_0.BANDGAP_0.x2.x6.D a_7023_7969# 0.07646f
C158 LELO_GR02_0.BANDGAP_0.x2.x6.D a_7023_8769# 0.07043f
C159 LELO_GR02_0.BANDGAP_0.x5.A LELO_GR02_0.BANDGAP_0.x4.D 1.82416f
C160 LELO_GR02_0.BANDGAP_0.x5.B LELO_GR02_0.BANDGAP_0.x4.D 0.94448f
C161 LELO_GR02_0.BANDGAP_0.x4.D LELO_GR02_0.BANDGAP_0.x8.DN 0.45024f
C162 LELO_GR02_0.OSCILLATOR_0.I_PTAT LELO_GR02_0.BANDGAP_0.x4.D 0.87018f
C163 LELO_GR02_0.OSCILLATOR_0.PWRUP_B_1V8 LELO_GR02_0.BANDGAP_0.x4.D 0.16274f
C164 LELO_GR02_0.OSCILLATOR_0.PWRUP_N_1V8 LELO_GR02_0.BANDGAP_0.x4.D 0.08792f
C165 LELO_GR02_0.OSCILLATOR_0.V_CTAT LELO_GR02_0.BANDGAP_0.x4.D 0.65763f
C166 LELO_GR02_0.BANDGAP_0.x4.D LELO_GR02_0.OSCILLATOR_0.x13<2>.B 0.01329f
C167 LELO_GR02_0.BANDGAP_0.x4.D VDPWR 1.20964f
C168 LELO_GR02_0.BANDGAP_0.x4.D VGND 3.71695f
C169 LELO_GR02_0.BANDGAP_0.x4.D a_11462_11348# 0.10805f
C170 LELO_GR02_0.BANDGAP_0.x4.D a_11894_11348# 0.10945f
C171 LELO_GR02_0.BANDGAP_0.x4.D a_12326_11348# 0.33641f
C172 LELO_GR02_0.BANDGAP_0.x4.D a_12974_9428# 0.02611f
C173 LELO_GR02_0.BANDGAP_0.x4.D a_5506_10332# 0.02413f
C174 LELO_GR02_0.BANDGAP_0.x4.D a_5506_11132# 0.01811f
C175 a_5506_11266# LELO_GR02_0.BANDGAP_0.x4.D 0.01827f
C176 a_5506_12066# LELO_GR02_0.BANDGAP_0.x4.D 0.03047f
C177 a_5506_12200# LELO_GR02_0.BANDGAP_0.x4.D 0.02903f
C178 LELO_GR02_0.BANDGAP_0.x4.D a_6392_9060# 0.06905f
C179 LELO_GR02_0.BANDGAP_0.x4.D a_6392_9860# 0.08329f
C180 a_7268_12066# LELO_GR02_0.BANDGAP_0.x4.D 0.0319f
C181 a_7268_12200# LELO_GR02_0.BANDGAP_0.x4.D 0.03471f
C182 LELO_GR02_0.BANDGAP_0.x4.D a_9590_11622# 0.01342f
C183 LELO_GR02_0.BANDGAP_0.x4.D a_9590_11782# 0.03093f
C184 a_9590_12262# LELO_GR02_0.BANDGAP_0.x4.D 0.03913f
C185 a_9590_12422# LELO_GR02_0.BANDGAP_0.x4.D 0.01626f
C186 LELO_GR02_0.BANDGAP_0.x5.A LELO_GR02_0.BANDGAP_0.x5.B 5.09878f
C187 LELO_GR02_0.BANDGAP_0.x5.A LELO_GR02_0.BANDGAP_0.x8.DN 0.02369f
C188 LELO_GR02_0.BANDGAP_0.x5.A LELO_GR02_0.OSCILLATOR_0.I_PTAT 1.47898f
C189 LELO_GR02_0.OSCILLATOR_0.PWRUP_N_1V8 LELO_GR02_0.BANDGAP_0.x5.A 0.22671f
C190 LELO_GR02_0.BANDGAP_0.x5.A LELO_GR02_0.OSCILLATOR_0.V_CTAT 0.88655f
C191 LELO_GR02_0.BANDGAP_0.x5.A VDPWR 3.00503f
C192 LELO_GR02_0.BANDGAP_0.x5.A VGND 0.7345f
C193 LELO_GR02_0.BANDGAP_0.x5.A a_8748_14798# 0.03616f
C194 LELO_GR02_0.BANDGAP_0.x5.A a_8748_14958# 0.04055f
C195 a_8748_15438# LELO_GR02_0.BANDGAP_0.x5.A 0.03833f
C196 a_8748_15598# LELO_GR02_0.BANDGAP_0.x5.A 0.01045f
C197 LELO_GR02_0.BANDGAP_0.x5.A a_9590_10585# 0.04215f
C198 LELO_GR02_0.BANDGAP_0.x5.A a_9590_10745# 0.05756f
C199 LELO_GR02_0.BANDGAP_0.x5.A a_9590_11225# 0.06019f
C200 LELO_GR02_0.BANDGAP_0.x5.A a_9590_11385# 0.04933f
C201 LELO_GR02_0.BANDGAP_0.x5.A a_9590_11622# 0.0498f
C202 LELO_GR02_0.BANDGAP_0.x5.A a_9590_11782# 0.0635f
C203 LELO_GR02_0.BANDGAP_0.x5.A a_9590_12262# 0.05615f
C204 LELO_GR02_0.BANDGAP_0.x5.A a_9590_12422# 0.04894f
C205 LELO_GR02_0.BANDGAP_0.x5.A a_9590_12661# 0.03813f
C206 LELO_GR02_0.BANDGAP_0.x5.A a_9590_12821# 0.05646f
C207 LELO_GR02_0.BANDGAP_0.x5.A a_9590_13301# 0.05648f
C208 LELO_GR02_0.BANDGAP_0.x5.A a_9590_13461# 0.03666f
C209 LELO_GR02_0.BANDGAP_0.x5.A a_9590_13714# 0.0361f
C210 LELO_GR02_0.BANDGAP_0.x5.A a_9590_13874# 0.05607f
C211 LELO_GR02_0.BANDGAP_0.x5.A a_9590_14354# 0.05631f
C212 LELO_GR02_0.BANDGAP_0.x5.A a_9590_14514# 0.03533f
C213 LELO_GR02_0.BANDGAP_0.x5.B LELO_GR02_0.BANDGAP_0.x8.DN 0.42252f
C214 LELO_GR02_0.BANDGAP_0.x5.B LELO_GR02_0.OSCILLATOR_0.I_PTAT 0.45747f
C215 LELO_GR02_0.OSCILLATOR_0.PWRUP_N_1V8 LELO_GR02_0.BANDGAP_0.x5.B 0.90892f
C216 LELO_GR02_0.BANDGAP_0.x5.B LELO_GR02_0.OSCILLATOR_0.V_CTAT 1.20574f
C217 LELO_GR02_0.BANDGAP_0.x5.B VDPWR 5.8592f
C218 LELO_GR02_0.BANDGAP_0.x5.B VGND 13.402f
C219 LELO_GR02_0.BANDGAP_0.x5.B a_5195_3790# 0.01622f
C220 LELO_GR02_0.BANDGAP_0.x5.B a_5411_3790# 0.01134f
C221 LELO_GR02_0.BANDGAP_0.x5.B a_6707_3790# 0.01139f
C222 LELO_GR02_0.BANDGAP_0.x5.B a_7023_7034# 0.01404f
C223 LELO_GR02_0.BANDGAP_0.x5.B a_7023_7834# 0.03136f
C224 LELO_GR02_0.BANDGAP_0.x5.B a_7023_7969# 0.03205f
C225 LELO_GR02_0.BANDGAP_0.x5.B a_7023_8769# 0.0438f
C226 LELO_GR02_0.BANDGAP_0.x5.B a_7139_3790# 0.01682f
C227 LELO_GR02_0.BANDGAP_0.x5.B a_7268_10332# 0.06758f
C228 LELO_GR02_0.BANDGAP_0.x5.B a_7268_11132# 0.03927f
C229 LELO_GR02_0.BANDGAP_0.x5.B a_7268_11266# 0.03896f
C230 LELO_GR02_0.BANDGAP_0.x5.B a_7268_12066# 0.03673f
C231 LELO_GR02_0.BANDGAP_0.x5.B a_7268_12200# 0.03634f
C232 LELO_GR02_0.BANDGAP_0.x5.B a_7268_13000# 0.03672f
C233 LELO_GR02_0.BANDGAP_0.x5.B a_7269_13136# 0.03669f
C234 a_7269_13936# LELO_GR02_0.BANDGAP_0.x5.B 0.01587f
C235 LELO_GR02_0.BANDGAP_0.x5.B a_7642_9058# 0.01954f
C236 LELO_GR02_0.BANDGAP_0.x5.B a_7642_9218# 0.04675f
C237 LELO_GR02_0.BANDGAP_0.x5.B a_7642_9698# 0.06013f
C238 LELO_GR02_0.BANDGAP_0.x5.B a_7642_9858# 0.04864f
C239 LELO_GR02_0.BANDGAP_0.x5.B a_9590_10585# 0.01661f
C240 LELO_GR02_0.BANDGAP_0.x5.B a_9590_10745# 0.08336f
C241 LELO_GR02_0.BANDGAP_0.x5.B a_9590_11225# 0.08125f
C242 LELO_GR02_0.BANDGAP_0.x5.B a_9590_11385# 0.01088f
C243 LELO_GR02_0.BANDGAP_0.x5.B a_9590_11622# 0.01082f
C244 LELO_GR02_0.BANDGAP_0.x5.B a_9590_11782# 0.08117f
C245 LELO_GR02_0.BANDGAP_0.x5.B a_9590_12262# 0.08122f
C246 LELO_GR02_0.BANDGAP_0.x5.B a_9590_12422# 0.01312f
C247 LELO_GR02_0.BANDGAP_0.x5.B a_9590_12661# 0.01276f
C248 LELO_GR02_0.BANDGAP_0.x5.B a_9590_12821# 0.08162f
C249 LELO_GR02_0.BANDGAP_0.x5.B a_9590_13301# 0.08179f
C250 LELO_GR02_0.BANDGAP_0.x5.B a_9590_13461# 0.01182f
C251 LELO_GR02_0.BANDGAP_0.x5.B a_9590_13714# 0.01116f
C252 LELO_GR02_0.BANDGAP_0.x5.B a_9590_13874# 0.08121f
C253 a_9590_14354# LELO_GR02_0.BANDGAP_0.x5.B 0.08074f
C254 LELO_GR02_0.OSCILLATOR_0.PWRUP_B_1V8 LELO_GR02_0.BANDGAP_0.x8.DN 0.42653f
C255 LELO_GR02_0.OSCILLATOR_0.V_CTAT LELO_GR02_0.BANDGAP_0.x8.DN 2.89478f
C256 LELO_GR02_0.BANDGAP_0.x8.DN VGND 16.6401f
C257 a_11030_9428# LELO_GR02_0.BANDGAP_0.x8.DN 0.30139f
C258 LELO_GR02_0.BANDGAP_0.x8.DN a_11246_9428# 0.2077f
C259 LELO_GR02_0.BANDGAP_0.x8.DN a_11462_11348# 0.25648f
C260 LELO_GR02_0.OSCILLATOR_0.PWRUP_B_1V8 LELO_GR02_0.OSCILLATOR_0.I_PTAT 1.40363f
C261 LELO_GR02_0.OSCILLATOR_0.PWRUP_N_1V8 LELO_GR02_0.OSCILLATOR_0.I_PTAT 2.72599f
C262 LELO_GR02_0.OSCILLATOR_0.V_CTAT LELO_GR02_0.OSCILLATOR_0.I_PTAT 3.47396f
C263 LELO_GR02_0.OSCILLATOR_0.I_PTAT LELO_GR02_0.OSCILLATOR_0.x13<2>.B 32.875f
C264 LELO_GR02_0.OSCILLATOR_0.x5.x11.G LELO_GR02_0.OSCILLATOR_0.I_PTAT 0.86577f
C265 LELO_GR02_0.OSCILLATOR_0.x5.x11.S LELO_GR02_0.OSCILLATOR_0.I_PTAT 0.84898f
C266 LELO_GR02_0.OSCILLATOR_0.x5.x9<4>.D LELO_GR02_0.OSCILLATOR_0.I_PTAT 1.90816f
C267 LELO_GR02_0.OSCILLATOR_0.I_PTAT LELO_GR02_0.OSCILLATOR_0.x5.x9<4>.S 4.5766f
C268 LELO_GR02_0.OSCILLATOR_0.I_PTAT LELO_GR02_0.OSCILLATOR_0.x6.CK 1.85684f
C269 LELO_GR02_0.OSCILLATOR_0.I_PTAT VDPWR 2.03331f
C270 LELO_GR02_0.OSCILLATOR_0.I_PTAT VGND 25.4629f
C271 LELO_GR02_0.OSCILLATOR_0.I_PTAT a_15861_10586# 0.02509f
C272 LELO_GR02_0.OSCILLATOR_0.I_PTAT a_15861_9786# 0.0281f
C273 LELO_GR02_0.OSCILLATOR_0.I_PTAT a_15861_9946# 0.01753f
C274 LELO_GR02_0.OSCILLATOR_0.I_PTAT a_16245_11265# 0.0576f
C275 LELO_GR02_0.OSCILLATOR_0.I_PTAT a_16245_12065# 0.07836f
C276 LELO_GR02_0.OSCILLATOR_0.I_PTAT a_17682_12715# 0.01654f
C277 LELO_GR02_0.OSCILLATOR_0.I_PTAT a_18932_10314# 0.07044f
C278 LELO_GR02_0.OSCILLATOR_0.I_PTAT a_18932_11114# 0.1428f
C279 LELO_GR02_0.OSCILLATOR_0.I_PTAT a_18932_11914# 0.14288f
C280 LELO_GR02_0.OSCILLATOR_0.I_PTAT a_18932_12714# 0.147f
C281 LELO_GR02_0.OSCILLATOR_0.I_PTAT a_18932_13514# 0.14279f
C282 LELO_GR02_0.OSCILLATOR_0.I_PTAT a_18932_14314# 0.07043f
C283 LELO_GR02_0.OSCILLATOR_0.I_PTAT a_9590_10585# 0.01076f
C284 LELO_GR02_0.OSCILLATOR_0.I_PTAT a_9590_10745# 0.029f
C285 LELO_GR02_0.OSCILLATOR_0.I_PTAT a_9590_11225# 0.03617f
C286 LELO_GR02_0.OSCILLATOR_0.I_PTAT a_9590_11385# 0.02183f
C287 LELO_GR02_0.OSCILLATOR_0.I_PTAT a_9590_12661# 0.02218f
C288 LELO_GR02_0.OSCILLATOR_0.I_PTAT a_9590_12821# 0.03769f
C289 a_9590_13301# LELO_GR02_0.OSCILLATOR_0.I_PTAT 0.02902f
C290 a_9590_13461# LELO_GR02_0.OSCILLATOR_0.I_PTAT 0.01077f
C291 LELO_GR02_0.OSCILLATOR_0.PWRUP_N_1V8 LELO_GR02_0.OSCILLATOR_0.PWRUP_B_1V8 0.73578f
C292 LELO_GR02_0.OSCILLATOR_0.PWRUP_B_1V8 LELO_GR02_0.OSCILLATOR_0.V_CTAT 0.92937f
C293 LELO_GR02_0.OSCILLATOR_0.PWRUP_B_1V8 LELO_GR02_0.OSCILLATOR_0.x13<2>.B 1.24472f
C294 LELO_GR02_0.OSCILLATOR_0.PWRUP_B_1V8 LELO_GR02_0.OSCILLATOR_0.x5.x11.S 0.15572f
C295 LELO_GR02_0.OSCILLATOR_0.PWRUP_B_1V8 LELO_GR02_0.OSCILLATOR_0.x5.x7.G 0.18759f
C296 LELO_GR02_0.OSCILLATOR_0.PWRUP_B_1V8 LELO_GR02_0.OSCILLATOR_0.x5.x9<4>.D 0.04969f
C297 LELO_GR02_0.OSCILLATOR_0.PWRUP_B_1V8 LELO_GR02_0.OSCILLATOR_0.x5.x9<4>.S 0.3855f
C298 LELO_GR02_0.OSCILLATOR_0.PWRUP_B_1V8 LELO_GR02_0.OSCILLATOR_0.x6.CK 0.70499f
C299 LELO_GR02_0.OSCILLATOR_0.PWRUP_B_1V8 LELO_GR02_0.OSCILLATOR_0.x6.D 0.07994f
C300 LELO_GR02_0.OSCILLATOR_0.PWRUP_B_1V8 LELO_GR02_0.OSCILLATOR_0.x6.XA5.A 0.07611f
C301 LELO_GR02_0.OSCILLATOR_0.PWRUP_B_1V8 LELO_GR02_0.OSCILLATOR_0.x6.XA6.A 0.05865f
C302 LELO_GR02_0.OSCILLATOR_0.PWRUP_B_1V8 LELO_GR02_0.OSCILLATOR_0.x6.XA7.C 0.47807f
C303 LELO_GR02_0.OSCILLATOR_0.PWRUP_B_1V8 LELO_GR02_0.OSCILLATOR_0.x6.XA7.CN 0.11034f
C304 LELO_GR02_0.OSCILLATOR_0.PWRUP_B_1V8 LELO_GR02_0.OSCILLATOR_0.x6.XA7.MP1.S 0.04378f
C305 LELO_GR02_0.OSCILLATOR_0.PWRUP_B_1V8 VDPWR 1.15967f
C306 LELO_GR02_0.OSCILLATOR_0.PWRUP_B_1V8 VGND 22.9038f
C307 LELO_GR02_0.OSCILLATOR_0.PWRUP_B_1V8 a_12542_9428# 0.01436f
C308 LELO_GR02_0.OSCILLATOR_0.PWRUP_B_1V8 a_12974_9428# 0.16302f
C309 LELO_GR02_0.OSCILLATOR_0.PWRUP_B_1V8 a_15861_10426# 0.08099f
C310 LELO_GR02_0.OSCILLATOR_0.PWRUP_B_1V8 a_15861_10586# 0.01533f
C311 LELO_GR02_0.OSCILLATOR_0.PWRUP_B_1V8 a_15861_9786# 0.01877f
C312 LELO_GR02_0.OSCILLATOR_0.PWRUP_B_1V8 a_15861_9946# 0.0956f
C313 LELO_GR02_0.OSCILLATOR_0.PWRUP_B_1V8 a_20745_11175# 0.06699f
C314 LELO_GR02_0.OSCILLATOR_0.PWRUP_B_1V8 a_20745_9095# 0.06788f
C315 LELO_GR02_0.OSCILLATOR_0.PWRUP_B_1V8 a_21585_11175# 0.06129f
C316 LELO_GR02_0.OSCILLATOR_0.PWRUP_B_1V8 a_21585_9095# 0.05912f
C317 LELO_GR02_0.OSCILLATOR_0.PWRUP_B_1V8 a_7758_17876# 0.01054f
C318 a_7758_18196# LELO_GR02_0.OSCILLATOR_0.PWRUP_B_1V8 0.01772f
C319 LELO_GR02_0.OSCILLATOR_0.PWRUP_B_1V8 a_8598_17876# 0.03093f
C320 a_8598_18196# LELO_GR02_0.OSCILLATOR_0.PWRUP_B_1V8 0.01809f
C321 LELO_GR02_0.OSCILLATOR_0.PWRUP_B_1V8 uo_out<0> 0.26095f
C322 LELO_GR02_0.OSCILLATOR_0.PWRUP_N_1V8 LELO_GR02_0.OSCILLATOR_0.V_CTAT 1.31855f
C323 LELO_GR02_0.OSCILLATOR_0.PWRUP_N_1V8 LELO_GR02_0.OSCILLATOR_0.x13<2>.B 0.1263f
C324 LELO_GR02_0.OSCILLATOR_0.PWRUP_N_1V8 LELO_GR02_0.OSCILLATOR_0.x5.x11.G 0.64323f
C325 LELO_GR02_0.OSCILLATOR_0.PWRUP_N_1V8 LELO_GR02_0.OSCILLATOR_0.x5.x11.S 3.05875f
C326 LELO_GR02_0.OSCILLATOR_0.PWRUP_N_1V8 LELO_GR02_0.OSCILLATOR_0.x5.x7.G 1.28857f
C327 LELO_GR02_0.OSCILLATOR_0.PWRUP_N_1V8 LELO_GR02_0.OSCILLATOR_0.x5.x9<4>.S 0.72181f
C328 LELO_GR02_0.OSCILLATOR_0.PWRUP_N_1V8 LELO_GR02_0.OSCILLATOR_0.x6.CK 1.32324f
C329 LELO_GR02_0.OSCILLATOR_0.PWRUP_N_1V8 VDPWR 7.5998f
C330 LELO_GR02_0.OSCILLATOR_0.PWRUP_N_1V8 VGND 23.1228f
C331 LELO_GR02_0.OSCILLATOR_0.PWRUP_N_1V8 a_17426_6526# 0.08443f
C332 LELO_GR02_0.OSCILLATOR_0.PWRUP_N_1V8 a_17426_7006# 0.09035f
C333 LELO_GR02_0.OSCILLATOR_0.PWRUP_N_1V8 a_17426_7122# 0.05348f
C334 LELO_GR02_0.OSCILLATOR_0.PWRUP_N_1V8 a_17426_7282# 0.09576f
C335 LELO_GR02_0.OSCILLATOR_0.PWRUP_N_1V8 a_17426_7762# 0.08988f
C336 LELO_GR02_0.OSCILLATOR_0.PWRUP_N_1V8 a_17426_7922# 0.01402f
C337 LELO_GR02_0.OSCILLATOR_0.PWRUP_N_1V8 a_18185_16361# 0.08518f
C338 LELO_GR02_0.OSCILLATOR_0.PWRUP_N_1V8 a_18185_16841# 0.08704f
C339 LELO_GR02_0.OSCILLATOR_0.PWRUP_N_1V8 a_18932_6526# 0.08371f
C340 LELO_GR02_0.OSCILLATOR_0.PWRUP_N_1V8 a_18932_7006# 0.08978f
C341 LELO_GR02_0.OSCILLATOR_0.PWRUP_N_1V8 a_18932_7122# 0.05088f
C342 LELO_GR02_0.OSCILLATOR_0.PWRUP_N_1V8 a_18932_7282# 0.09016f
C343 LELO_GR02_0.OSCILLATOR_0.PWRUP_N_1V8 a_18932_7762# 0.08373f
C344 LELO_GR02_0.OSCILLATOR_0.PWRUP_N_1V8 a_20984_6987# 0.08081f
C345 LELO_GR02_0.OSCILLATOR_0.PWRUP_N_1V8 a_20984_7467# 0.08111f
C346 LELO_GR02_0.OSCILLATOR_0.PWRUP_N_1V8 a_3635_9219# 0.08291f
C347 LELO_GR02_0.OSCILLATOR_0.PWRUP_N_1V8 a_3635_9699# 0.08761f
C348 LELO_GR02_0.OSCILLATOR_0.PWRUP_N_1V8 a_3635_9859# 0.03597f
C349 LELO_GR02_0.OSCILLATOR_0.PWRUP_N_1V8 a_3743_10332# 0.01566f
C350 LELO_GR02_0.OSCILLATOR_0.PWRUP_N_1V8 a_5141_9860# 0.01241f
C351 LELO_GR02_0.OSCILLATOR_0.PWRUP_N_1V8 a_5506_10332# 0.01516f
C352 LELO_GR02_0.OSCILLATOR_0.PWRUP_N_1V8 a_5664_14810# 0.03105f
C353 LELO_GR02_0.OSCILLATOR_0.PWRUP_N_1V8 a_5664_14970# 0.09353f
C354 LELO_GR02_0.OSCILLATOR_0.PWRUP_N_1V8 a_5664_15450# 0.08415f
C355 LELO_GR02_0.OSCILLATOR_0.PWRUP_N_1V8 a_7642_9218# 0.08074f
C356 LELO_GR02_0.OSCILLATOR_0.PWRUP_N_1V8 a_7642_9698# 0.08096f
C357 LELO_GR02_0.OSCILLATOR_0.PWRUP_N_1V8 a_7642_9858# 0.02404f
C358 LELO_GR02_0.OSCILLATOR_0.PWRUP_N_1V8 a_7758_17876# 0.10719f
C359 LELO_GR02_0.OSCILLATOR_0.PWRUP_N_1V8 a_7758_18196# 0.09584f
C360 LELO_GR02_0.OSCILLATOR_0.PWRUP_N_1V8 a_7758_18706# 0.01351f
C361 a_7758_19026# LELO_GR02_0.OSCILLATOR_0.PWRUP_N_1V8 0.01772f
C362 LELO_GR02_0.OSCILLATOR_0.PWRUP_N_1V8 a_8598_17876# 0.06459f
C363 LELO_GR02_0.OSCILLATOR_0.PWRUP_N_1V8 a_8598_18196# 0.05997f
C364 a_8598_19026# LELO_GR02_0.OSCILLATOR_0.PWRUP_N_1V8 0.01772f
C365 LELO_GR02_0.OSCILLATOR_0.PWRUP_N_1V8 a_8748_14798# 0.01616f
C366 LELO_GR02_0.OSCILLATOR_0.PWRUP_N_1V8 a_8748_14958# 0.08256f
C367 LELO_GR02_0.OSCILLATOR_0.PWRUP_N_1V8 a_8748_15438# 0.08184f
C368 LELO_GR02_0.OSCILLATOR_0.PWRUP_N_1V8 m1_5524_9447# 0.01026f
C369 LELO_GR02_0.OSCILLATOR_0.PWRUP_N_1V8 ui_in<0> 0.14929f
C370 LELO_GR02_0.OSCILLATOR_0.V_CTAT LELO_GR02_0.OSCILLATOR_0.x13<2>.B 0.99148f
C371 LELO_GR02_0.OSCILLATOR_0.x5.x11.G LELO_GR02_0.OSCILLATOR_0.V_CTAT 1.86459f
C372 LELO_GR02_0.OSCILLATOR_0.x5.x11.S LELO_GR02_0.OSCILLATOR_0.V_CTAT 0.04764f
C373 LELO_GR02_0.OSCILLATOR_0.V_CTAT LELO_GR02_0.OSCILLATOR_0.x5.x9<4>.S 3.34753f
C374 LELO_GR02_0.OSCILLATOR_0.V_CTAT LELO_GR02_0.OSCILLATOR_0.x6.CK 0.22732f
C375 LELO_GR02_0.OSCILLATOR_0.V_CTAT VDPWR 1.47183f
C376 LELO_GR02_0.OSCILLATOR_0.V_CTAT VGND 20.4813f
C377 LELO_GR02_0.OSCILLATOR_0.V_CTAT a_11030_9428# 0.03408f
C378 LELO_GR02_0.OSCILLATOR_0.V_CTAT a_11246_9428# 0.02814f
C379 LELO_GR02_0.OSCILLATOR_0.V_CTAT a_11678_9428# 0.02189f
C380 LELO_GR02_0.OSCILLATOR_0.V_CTAT a_12110_9428# 0.01776f
C381 LELO_GR02_0.OSCILLATOR_0.V_CTAT a_12542_9428# 0.01501f
C382 LELO_GR02_0.OSCILLATOR_0.V_CTAT a_12974_9428# 0.04613f
C383 LELO_GR02_0.OSCILLATOR_0.V_CTAT a_15861_10426# 0.02466f
C384 LELO_GR02_0.OSCILLATOR_0.V_CTAT a_15861_10586# 0.01332f
C385 LELO_GR02_0.OSCILLATOR_0.V_CTAT a_17682_10315# 0.0876f
C386 LELO_GR02_0.OSCILLATOR_0.V_CTAT a_17682_11115# 0.14277f
C387 LELO_GR02_0.OSCILLATOR_0.V_CTAT a_17682_11915# 0.14277f
C388 LELO_GR02_0.OSCILLATOR_0.V_CTAT a_17682_12715# 0.14277f
C389 LELO_GR02_0.OSCILLATOR_0.V_CTAT a_17682_13515# 0.14277f
C390 LELO_GR02_0.OSCILLATOR_0.V_CTAT a_17682_14315# 0.07043f
C391 LELO_GR02_0.OSCILLATOR_0.V_CTAT a_5141_9060# 0.06933f
C392 LELO_GR02_0.OSCILLATOR_0.V_CTAT a_5141_9860# 0.07946f
C393 LELO_GR02_0.OSCILLATOR_0.V_CTAT a_6392_9860# 0.01542f
C394 LELO_GR02_0.OSCILLATOR_0.V_CTAT a_7642_9698# 0.01265f
C395 LELO_GR02_0.OSCILLATOR_0.V_CTAT a_7642_9858# 0.0246f
C396 LELO_GR02_0.OSCILLATOR_0.V_CTAT a_9590_10585# 0.01155f
C397 LELO_GR02_0.OSCILLATOR_0.V_CTAT a_9590_13714# 0.01608f
C398 LELO_GR02_0.OSCILLATOR_0.V_CTAT a_9590_13874# 0.0362f
C399 a_9590_14354# LELO_GR02_0.OSCILLATOR_0.V_CTAT 0.02923f
C400 a_9590_14514# LELO_GR02_0.OSCILLATOR_0.V_CTAT 0.01027f
C401 LELO_GR02_0.OSCILLATOR_0.V_CTAT m1_5524_9447# 0.04223f
C402 LELO_GR02_0.OSCILLATOR_0.x5.x11.G LELO_GR02_0.OSCILLATOR_0.x13<2>.B 0.02587f
C403 LELO_GR02_0.OSCILLATOR_0.x5.x11.S LELO_GR02_0.OSCILLATOR_0.x13<2>.B 0.03055f
C404 LELO_GR02_0.OSCILLATOR_0.x13<2>.B LELO_GR02_0.OSCILLATOR_0.x5.x9<4>.S 0.04789f
C405 LELO_GR02_0.OSCILLATOR_0.x6.CK LELO_GR02_0.OSCILLATOR_0.x13<2>.B 0.55125f
C406 LELO_GR02_0.OSCILLATOR_0.x13<2>.B VDPWR 0.07075f
C407 LELO_GR02_0.OSCILLATOR_0.x13<2>.B VGND 10.0073f
C408 a_12974_9428# LELO_GR02_0.OSCILLATOR_0.x13<2>.B 0.02027f
C409 LELO_GR02_0.OSCILLATOR_0.x13<2>.B a_15861_10426# 0.04654f
C410 LELO_GR02_0.OSCILLATOR_0.x13<2>.B a_15861_10586# 0.10216f
C411 LELO_GR02_0.OSCILLATOR_0.x13<2>.B a_15861_9786# 0.01102f
C412 LELO_GR02_0.OSCILLATOR_0.x13<2>.B a_15861_9946# 0.04535f
C413 LELO_GR02_0.OSCILLATOR_0.x13<2>.B a_16245_11265# 0.07726f
C414 a_16245_12065# LELO_GR02_0.OSCILLATOR_0.x13<2>.B 0.01323f
C415 LELO_GR02_0.OSCILLATOR_0.x5.x11.S LELO_GR02_0.OSCILLATOR_0.x5.x11.G 2.94839f
C416 LELO_GR02_0.OSCILLATOR_0.x5.x11.G LELO_GR02_0.OSCILLATOR_0.x5.x7.G 0.01034f
C417 LELO_GR02_0.OSCILLATOR_0.x5.x11.G LELO_GR02_0.OSCILLATOR_0.x5.x9<4>.D 0.38801f
C418 LELO_GR02_0.OSCILLATOR_0.x5.x11.G LELO_GR02_0.OSCILLATOR_0.x5.x9<4>.S 3.04304f
C419 LELO_GR02_0.OSCILLATOR_0.x5.x11.G LELO_GR02_0.OSCILLATOR_0.x6.CK 0.1954f
C420 LELO_GR02_0.OSCILLATOR_0.x5.x11.G VDPWR 3.78215f
C421 LELO_GR02_0.OSCILLATOR_0.x5.x11.G VGND 1.44278f
C422 LELO_GR02_0.OSCILLATOR_0.x5.x11.G a_17682_10315# 0.013f
C423 LELO_GR02_0.OSCILLATOR_0.x5.x11.G a_17682_11115# 0.03425f
C424 LELO_GR02_0.OSCILLATOR_0.x5.x11.G a_17682_11915# 0.03428f
C425 LELO_GR02_0.OSCILLATOR_0.x5.x11.G a_17682_12715# 0.03428f
C426 LELO_GR02_0.OSCILLATOR_0.x5.x11.G a_17682_13515# 0.03436f
C427 LELO_GR02_0.OSCILLATOR_0.x5.x11.G a_17682_14315# 0.04072f
C428 LELO_GR02_0.OSCILLATOR_0.x5.x11.G a_17682_14700# 0.11676f
C429 a_17682_15500# LELO_GR02_0.OSCILLATOR_0.x5.x11.G 0.08437f
C430 LELO_GR02_0.OSCILLATOR_0.x5.x11.G a_18932_14700# 0.07169f
C431 LELO_GR02_0.OSCILLATOR_0.x5.x11.G a_18932_15500# 0.07043f
C432 LELO_GR02_0.OSCILLATOR_0.x5.x11.S LELO_GR02_0.OSCILLATOR_0.x5.x7.G 1.27943f
C433 LELO_GR02_0.OSCILLATOR_0.x5.x11.S LELO_GR02_0.OSCILLATOR_0.x5.x9<4>.D 1.19479f
C434 LELO_GR02_0.OSCILLATOR_0.x5.x11.S LELO_GR02_0.OSCILLATOR_0.x5.x9<4>.S 1.50749f
C435 LELO_GR02_0.OSCILLATOR_0.x5.x11.S LELO_GR02_0.OSCILLATOR_0.x6.CK 0.89646f
C436 LELO_GR02_0.OSCILLATOR_0.x5.x11.S VDPWR 7.7103f
C437 LELO_GR02_0.OSCILLATOR_0.x5.x11.S VGND 9.19675f
C438 LELO_GR02_0.OSCILLATOR_0.x5.x11.S a_16918_2966# 0.01759f
C439 LELO_GR02_0.OSCILLATOR_0.x5.x11.S a_17350_4886# 0.47691f
C440 LELO_GR02_0.OSCILLATOR_0.x5.x11.S a_17682_14700# 0.05869f
C441 LELO_GR02_0.OSCILLATOR_0.x5.x11.S a_17682_15500# 0.09084f
C442 LELO_GR02_0.OSCILLATOR_0.x5.x11.S a_17782_4886# 0.11845f
C443 LELO_GR02_0.OSCILLATOR_0.x5.x11.S a_18185_16201# 0.02838f
C444 LELO_GR02_0.OSCILLATOR_0.x5.x11.S a_18185_16361# 0.05179f
C445 a_18185_16841# LELO_GR02_0.OSCILLATOR_0.x5.x11.S 0.06101f
C446 a_18185_17001# LELO_GR02_0.OSCILLATOR_0.x5.x11.S 0.12452f
C447 LELO_GR02_0.OSCILLATOR_0.x5.x11.S a_18214_4886# 0.04412f
C448 LELO_GR02_0.OSCILLATOR_0.x5.x11.S a_18323_9235# 0.01065f
C449 LELO_GR02_0.OSCILLATOR_0.x5.x11.S a_18646_4886# 0.03867f
C450 LELO_GR02_0.OSCILLATOR_0.x5.x11.S a_18932_14700# 0.06235f
C451 LELO_GR02_0.OSCILLATOR_0.x5.x11.S a_18932_15500# 0.06955f
C452 LELO_GR02_0.OSCILLATOR_0.x5.x11.S a_20567_12681# 0.05639f
C453 LELO_GR02_0.OSCILLATOR_0.x5.x11.S a_20567_13481# 0.07433f
C454 LELO_GR02_0.OSCILLATOR_0.x5.x11.S uo_out<0> 0.20285f
C455 LELO_GR02_0.OSCILLATOR_0.x5.x9<4>.S LELO_GR02_0.OSCILLATOR_0.x5.x7.G 0.39882f
C456 LELO_GR02_0.OSCILLATOR_0.x6.CK LELO_GR02_0.OSCILLATOR_0.x5.x7.G 0.4479f
C457 LELO_GR02_0.OSCILLATOR_0.x5.x7.G VGND 12.8543f
C458 LELO_GR02_0.OSCILLATOR_0.x5.x7.G a_17426_6366# 0.02792f
C459 LELO_GR02_0.OSCILLATOR_0.x5.x7.G a_17426_6526# 0.03899f
C460 LELO_GR02_0.OSCILLATOR_0.x5.x7.G a_17426_7006# 0.0375f
C461 LELO_GR02_0.OSCILLATOR_0.x5.x7.G a_17426_7122# 0.05013f
C462 LELO_GR02_0.OSCILLATOR_0.x5.x7.G a_17426_7282# 0.03805f
C463 LELO_GR02_0.OSCILLATOR_0.x5.x7.G a_17426_7762# 0.0404f
C464 LELO_GR02_0.OSCILLATOR_0.x5.x7.G a_17426_7922# 0.03459f
C465 LELO_GR02_0.OSCILLATOR_0.x5.x7.G a_17682_8056# 0.10571f
C466 LELO_GR02_0.OSCILLATOR_0.x5.x7.G a_17682_8856# 0.08512f
C467 LELO_GR02_0.OSCILLATOR_0.x5.x7.G a_17782_4886# 0.01814f
C468 LELO_GR02_0.OSCILLATOR_0.x5.x7.G a_18214_4886# 0.27303f
C469 a_18323_10035# LELO_GR02_0.OSCILLATOR_0.x5.x7.G 0.07044f
C470 LELO_GR02_0.OSCILLATOR_0.x5.x7.G a_18323_9235# 0.08427f
C471 LELO_GR02_0.OSCILLATOR_0.x5.x7.G a_18646_4886# 0.26329f
C472 LELO_GR02_0.OSCILLATOR_0.x5.x7.G a_18932_7922# 0.01111f
C473 LELO_GR02_0.OSCILLATOR_0.x5.x7.G a_18932_8056# 0.0719f
C474 LELO_GR02_0.OSCILLATOR_0.x5.x7.G a_18932_8856# 0.06944f
C475 LELO_GR02_0.OSCILLATOR_0.x5.x7.G a_19078_4886# 0.26272f
C476 LELO_GR02_0.OSCILLATOR_0.x5.x7.G a_19510_4886# 0.26263f
C477 LELO_GR02_0.OSCILLATOR_0.x5.x7.G a_19942_4886# 0.47606f
C478 LELO_GR02_0.OSCILLATOR_0.x5.x7.G a_20590_2966# 0.01634f
C479 LELO_GR02_0.OSCILLATOR_0.x5.x9<4>.D LELO_GR02_0.OSCILLATOR_0.x5.x9<4>.S 1.99743f
C480 LELO_GR02_0.OSCILLATOR_0.x5.x9<4>.D LELO_GR02_0.OSCILLATOR_0.x6.CK 0.77945f
C481 LELO_GR02_0.OSCILLATOR_0.x5.x9<4>.D VDPWR 2.14048f
C482 LELO_GR02_0.OSCILLATOR_0.x5.x9<4>.D VGND 1.48323f
C483 LELO_GR02_0.OSCILLATOR_0.x5.x9<4>.D a_18932_10314# 0.013f
C484 LELO_GR02_0.OSCILLATOR_0.x5.x9<4>.D a_18932_11114# 0.03425f
C485 LELO_GR02_0.OSCILLATOR_0.x5.x9<4>.D a_18932_11914# 0.03457f
C486 LELO_GR02_0.OSCILLATOR_0.x5.x9<4>.D a_18932_12714# 0.03624f
C487 LELO_GR02_0.OSCILLATOR_0.x5.x9<4>.D a_18932_13514# 0.03483f
C488 LELO_GR02_0.OSCILLATOR_0.x5.x9<4>.D a_18932_14314# 0.03702f
C489 LELO_GR02_0.OSCILLATOR_0.x5.x9<4>.D a_18932_14700# 0.03705f
C490 a_18932_15500# LELO_GR02_0.OSCILLATOR_0.x5.x9<4>.D 0.013f
C491 LELO_GR02_0.OSCILLATOR_0.x5.x9<4>.D a_20567_12681# 0.0713f
C492 LELO_GR02_0.OSCILLATOR_0.x5.x9<4>.D a_20567_13481# 0.07106f
C493 LELO_GR02_0.OSCILLATOR_0.x6.CK LELO_GR02_0.OSCILLATOR_0.x5.x9<4>.S 0.54121f
C494 LELO_GR02_0.OSCILLATOR_0.x5.x9<4>.S VDPWR 0.05864f
C495 LELO_GR02_0.OSCILLATOR_0.x5.x9<4>.S VGND 4.03816f
C496 LELO_GR02_0.OSCILLATOR_0.x5.x9<4>.S a_17682_10315# 0.07111f
C497 LELO_GR02_0.OSCILLATOR_0.x5.x9<4>.S a_17682_11115# 0.12267f
C498 LELO_GR02_0.OSCILLATOR_0.x5.x9<4>.S a_17682_11915# 0.1269f
C499 LELO_GR02_0.OSCILLATOR_0.x5.x9<4>.S a_17682_12715# 0.12094f
C500 LELO_GR02_0.OSCILLATOR_0.x5.x9<4>.S a_17682_13515# 0.12281f
C501 a_17682_14315# LELO_GR02_0.OSCILLATOR_0.x5.x9<4>.S 0.06612f
C502 LELO_GR02_0.OSCILLATOR_0.x5.x9<4>.S a_18323_10035# 0.04365f
C503 LELO_GR02_0.OSCILLATOR_0.x5.x9<4>.S a_18323_9235# 0.01351f
C504 LELO_GR02_0.OSCILLATOR_0.x5.x9<4>.S a_18932_10314# 0.06635f
C505 LELO_GR02_0.OSCILLATOR_0.x5.x9<4>.S a_18932_11114# 0.12007f
C506 LELO_GR02_0.OSCILLATOR_0.x5.x9<4>.S a_18932_11914# 0.12062f
C507 LELO_GR02_0.OSCILLATOR_0.x5.x9<4>.S a_18932_12714# 0.12009f
C508 LELO_GR02_0.OSCILLATOR_0.x5.x9<4>.S a_18932_13514# 0.12008f
C509 LELO_GR02_0.OSCILLATOR_0.x5.x9<4>.S a_18932_14314# 0.0583f
C510 LELO_GR02_0.OSCILLATOR_0.x6.CK LELO_GR02_0.OSCILLATOR_0.x6.D 0.03708f
C511 LELO_GR02_0.OSCILLATOR_0.x6.CK LELO_GR02_0.OSCILLATOR_0.x6.XA7.C 0.14793f
C512 LELO_GR02_0.OSCILLATOR_0.x6.CK LELO_GR02_0.OSCILLATOR_0.x6.XA7.CN 0.0164f
C513 LELO_GR02_0.OSCILLATOR_0.x6.CK VDPWR 1.22169f
C514 LELO_GR02_0.OSCILLATOR_0.x6.CK VGND 10.818f
C515 LELO_GR02_0.OSCILLATOR_0.x6.CK a_16245_11265# 0.0771f
C516 a_16245_12065# LELO_GR02_0.OSCILLATOR_0.x6.CK 0.07098f
C517 LELO_GR02_0.OSCILLATOR_0.x6.CK a_18932_6366# 0.01021f
C518 LELO_GR02_0.OSCILLATOR_0.x6.CK a_18932_6526# 0.03815f
C519 LELO_GR02_0.OSCILLATOR_0.x6.CK a_18932_7006# 0.03768f
C520 LELO_GR02_0.OSCILLATOR_0.x6.CK a_18932_7122# 0.05068f
C521 LELO_GR02_0.OSCILLATOR_0.x6.CK a_18932_7282# 0.03827f
C522 LELO_GR02_0.OSCILLATOR_0.x6.CK a_18932_7762# 0.04513f
C523 LELO_GR02_0.OSCILLATOR_0.x6.CK a_18932_7922# 0.04696f
C524 LELO_GR02_0.OSCILLATOR_0.x6.CK a_18932_8056# 0.03385f
C525 LELO_GR02_0.OSCILLATOR_0.x6.CK a_18932_8856# 0.01016f
C526 LELO_GR02_0.OSCILLATOR_0.x6.CK a_20567_12681# 0.03784f
C527 LELO_GR02_0.OSCILLATOR_0.x6.CK a_20567_13481# 0.01422f
C528 LELO_GR02_0.OSCILLATOR_0.x6.CK a_20745_8615# 0.0634f
C529 LELO_GR02_0.OSCILLATOR_0.x6.CK a_20984_6827# 0.01307f
C530 LELO_GR02_0.OSCILLATOR_0.x6.CK a_20984_6987# 0.04241f
C531 LELO_GR02_0.OSCILLATOR_0.x6.CK a_20984_7467# 0.04719f
C532 LELO_GR02_0.OSCILLATOR_0.x6.CK a_20984_7627# 0.03023f
C533 LELO_GR02_0.OSCILLATOR_0.x6.CK a_21585_8615# 0.0615f
C534 LELO_GR02_0.OSCILLATOR_0.x6.CK uo_out<0> 0.05969f
C535 LELO_GR02_0.OSCILLATOR_0.x6.D LELO_GR02_0.OSCILLATOR_0.x6.XA5.A 0.03009f
C536 LELO_GR02_0.OSCILLATOR_0.x6.D LELO_GR02_0.OSCILLATOR_0.x6.XA6.A 0.08816f
C537 LELO_GR02_0.OSCILLATOR_0.x6.D LELO_GR02_0.OSCILLATOR_0.x6.XA6.MN1.S 0.05588f
C538 LELO_GR02_0.OSCILLATOR_0.x6.D LELO_GR02_0.OSCILLATOR_0.x6.XA6.MP1.S 0.04373f
C539 LELO_GR02_0.OSCILLATOR_0.x6.D LELO_GR02_0.OSCILLATOR_0.x6.XA7.C 0.77637f
C540 LELO_GR02_0.OSCILLATOR_0.x6.D LELO_GR02_0.OSCILLATOR_0.x6.XA7.CN 0.4483f
C541 LELO_GR02_0.OSCILLATOR_0.x6.D LELO_GR02_0.OSCILLATOR_0.x6.XA7.MN0.S 0.01878f
C542 LELO_GR02_0.OSCILLATOR_0.x6.D LELO_GR02_0.OSCILLATOR_0.x6.XA7.MP1.S 0.33356f
C543 LELO_GR02_0.OSCILLATOR_0.x6.D VDPWR 2.67074f
C544 LELO_GR02_0.OSCILLATOR_0.x6.D VGND 1.80989f
C545 LELO_GR02_0.OSCILLATOR_0.x6.D a_20745_11175# 0.03052f
C546 LELO_GR02_0.OSCILLATOR_0.x6.D a_20745_11815# 0.11369f
C547 a_20745_12135# LELO_GR02_0.OSCILLATOR_0.x6.D 0.12534f
C548 LELO_GR02_0.OSCILLATOR_0.x6.D a_20745_9415# 0.05912f
C549 LELO_GR02_0.OSCILLATOR_0.x6.D a_21585_11175# 0.02572f
C550 LELO_GR02_0.OSCILLATOR_0.x6.D a_21585_11815# 0.08594f
C551 a_21585_12135# LELO_GR02_0.OSCILLATOR_0.x6.D 0.11261f
C552 LELO_GR02_0.OSCILLATOR_0.x6.D a_21585_9415# 0.06129f
C553 LELO_GR02_0.OSCILLATOR_0.x6.D uo_out<0> 0.55155f
C554 LELO_GR02_0.OSCILLATOR_0.x6.XA7.C LELO_GR02_0.OSCILLATOR_0.x6.XA1.MN1.S 0.07714f
C555 LELO_GR02_0.OSCILLATOR_0.x6.XA1.MN1.S VGND 0.0969f
C556 LELO_GR02_0.OSCILLATOR_0.x6.XA5.A LELO_GR02_0.OSCILLATOR_0.x6.XA3.MN1.S 0.04373f
C557 LELO_GR02_0.OSCILLATOR_0.x6.XA7.C LELO_GR02_0.OSCILLATOR_0.x6.XA3.MN1.S 0.01916f
C558 LELO_GR02_0.OSCILLATOR_0.x6.XA7.CN LELO_GR02_0.OSCILLATOR_0.x6.XA3.MN1.S 0.0238f
C559 LELO_GR02_0.OSCILLATOR_0.x6.XA3.MN1.S VGND 0.09448f
C560 LELO_GR02_0.OSCILLATOR_0.x6.XA5.A LELO_GR02_0.OSCILLATOR_0.x6.XA3.MP1.S 0.04373f
C561 LELO_GR02_0.OSCILLATOR_0.x6.XA7.CN LELO_GR02_0.OSCILLATOR_0.x6.XA3.MP1.S 0.03112f
C562 LELO_GR02_0.OSCILLATOR_0.x6.XA3.MP1.S VDPWR 0.09448f
C563 LELO_GR02_0.OSCILLATOR_0.x6.XA5.A LELO_GR02_0.OSCILLATOR_0.x6.XA4.MN1.S 0.07879f
C564 LELO_GR02_0.OSCILLATOR_0.x6.XA7.CN LELO_GR02_0.OSCILLATOR_0.x6.XA4.MN1.S 0.03049f
C565 LELO_GR02_0.OSCILLATOR_0.x6.XA4.MN1.S VGND 0.08682f
C566 LELO_GR02_0.OSCILLATOR_0.x6.XA5.A LELO_GR02_0.OSCILLATOR_0.x6.XA4.MP1.S 0.05173f
C567 LELO_GR02_0.OSCILLATOR_0.x6.XA6.A LELO_GR02_0.OSCILLATOR_0.x6.XA4.MP1.S 0.01889f
C568 LELO_GR02_0.OSCILLATOR_0.x6.XA7.CN LELO_GR02_0.OSCILLATOR_0.x6.XA4.MP1.S 0.02318f
C569 LELO_GR02_0.OSCILLATOR_0.x6.XA4.MP1.S VDPWR 0.09448f
C570 LELO_GR02_0.OSCILLATOR_0.x6.XA6.A LELO_GR02_0.OSCILLATOR_0.x6.XA5.A 0.22909f
C571 LELO_GR02_0.OSCILLATOR_0.x6.XA7.C LELO_GR02_0.OSCILLATOR_0.x6.XA5.A 0.08968f
C572 LELO_GR02_0.OSCILLATOR_0.x6.XA7.CN LELO_GR02_0.OSCILLATOR_0.x6.XA5.A 0.38708f
C573 LELO_GR02_0.OSCILLATOR_0.x6.XA5.A VDPWR 0.66668f
C574 LELO_GR02_0.OSCILLATOR_0.x6.XA5.A VGND 0.99883f
C575 LELO_GR02_0.OSCILLATOR_0.x6.XA5.A a_20745_10375# 0.09561f
C576 a_20745_10695# LELO_GR02_0.OSCILLATOR_0.x6.XA5.A 0.06582f
C577 LELO_GR02_0.OSCILLATOR_0.x6.XA5.A a_20745_9895# 0.02736f
C578 LELO_GR02_0.OSCILLATOR_0.x6.XA5.A a_21585_10375# 0.07964f
C579 a_21585_10695# LELO_GR02_0.OSCILLATOR_0.x6.XA5.A 0.05912f
C580 LELO_GR02_0.OSCILLATOR_0.x6.XA5.A a_21585_9895# 0.02049f
C581 LELO_GR02_0.OSCILLATOR_0.x6.XA7.C LELO_GR02_0.OSCILLATOR_0.x6.XA6.A 0.58714f
C582 LELO_GR02_0.OSCILLATOR_0.x6.XA7.CN LELO_GR02_0.OSCILLATOR_0.x6.XA6.A 0.66396f
C583 LELO_GR02_0.OSCILLATOR_0.x6.XA6.A VDPWR 1.27634f
C584 LELO_GR02_0.OSCILLATOR_0.x6.XA6.A VGND 0.97625f
C585 LELO_GR02_0.OSCILLATOR_0.x6.XA6.A a_20745_10695# 0.0777f
C586 LELO_GR02_0.OSCILLATOR_0.x6.XA6.A a_20745_9895# 0.05912f
C587 LELO_GR02_0.OSCILLATOR_0.x6.XA6.A a_21585_10375# 0.01281f
C588 LELO_GR02_0.OSCILLATOR_0.x6.XA6.A a_21585_10695# 0.09795f
C589 LELO_GR02_0.OSCILLATOR_0.x6.XA6.A a_21585_9895# 0.06533f
C590 LELO_GR02_0.OSCILLATOR_0.x6.XA6.A uo_out<0> 0.01049f
C591 LELO_GR02_0.OSCILLATOR_0.x6.XA7.C LELO_GR02_0.OSCILLATOR_0.x6.XA6.MN1.S 0.01275f
C592 LELO_GR02_0.OSCILLATOR_0.x6.XA7.CN LELO_GR02_0.OSCILLATOR_0.x6.XA6.MN1.S 0.03056f
C593 LELO_GR02_0.OSCILLATOR_0.x6.XA6.MN1.S VGND 0.08222f
C594 LELO_GR02_0.OSCILLATOR_0.x6.XA7.C LELO_GR02_0.OSCILLATOR_0.x6.XA6.MP1.S 0.02158f
C595 LELO_GR02_0.OSCILLATOR_0.x6.XA7.CN LELO_GR02_0.OSCILLATOR_0.x6.XA6.MP1.S 0.02377f
C596 LELO_GR02_0.OSCILLATOR_0.x6.XA6.MP1.S VDPWR 0.08476f
C597 LELO_GR02_0.OSCILLATOR_0.x6.XA7.C LELO_GR02_0.OSCILLATOR_0.x6.XA7.CN 0.47812f
C598 LELO_GR02_0.OSCILLATOR_0.x6.XA7.C LELO_GR02_0.OSCILLATOR_0.x6.XA7.MP1.S 0.04215f
C599 LELO_GR02_0.OSCILLATOR_0.x6.XA7.C VDPWR 2.5971f
C600 LELO_GR02_0.OSCILLATOR_0.x6.XA7.C VGND 2.59743f
C601 LELO_GR02_0.OSCILLATOR_0.x6.XA7.C a_20745_11175# 0.01225f
C602 a_20745_11815# LELO_GR02_0.OSCILLATOR_0.x6.XA7.C 0.06698f
C603 LELO_GR02_0.OSCILLATOR_0.x6.XA7.C a_20745_9095# 0.09819f
C604 LELO_GR02_0.OSCILLATOR_0.x6.XA7.C a_20745_9415# 0.07292f
C605 LELO_GR02_0.OSCILLATOR_0.x6.XA7.C a_20745_9895# 0.06576f
C606 LELO_GR02_0.OSCILLATOR_0.x6.XA7.C a_21585_10375# 0.06664f
C607 LELO_GR02_0.OSCILLATOR_0.x6.XA7.C a_21585_11175# 0.06949f
C608 LELO_GR02_0.OSCILLATOR_0.x6.XA7.C a_21585_9095# 0.1046f
C609 LELO_GR02_0.OSCILLATOR_0.x6.XA7.C a_21585_9415# 0.06658f
C610 LELO_GR02_0.OSCILLATOR_0.x6.XA7.C uo_out<0> 0.15961f
C611 LELO_GR02_0.OSCILLATOR_0.x6.XA7.CN LELO_GR02_0.OSCILLATOR_0.x6.XA7.MP1.S 0.07161f
C612 LELO_GR02_0.OSCILLATOR_0.x6.XA7.CN VDPWR 1.37331f
C613 LELO_GR02_0.OSCILLATOR_0.x6.XA7.CN VGND 1.44236f
C614 LELO_GR02_0.OSCILLATOR_0.x6.XA7.CN a_20745_10375# 0.08881f
C615 LELO_GR02_0.OSCILLATOR_0.x6.XA7.CN a_20745_10695# 0.02661f
C616 LELO_GR02_0.OSCILLATOR_0.x6.XA7.CN a_20745_11175# 0.06325f
C617 LELO_GR02_0.OSCILLATOR_0.x6.XA7.CN a_20745_9415# 0.04737f
C618 LELO_GR02_0.OSCILLATOR_0.x6.XA7.CN a_20745_9895# 0.02602f
C619 LELO_GR02_0.OSCILLATOR_0.x6.XA7.CN a_21585_10375# 0.02605f
C620 LELO_GR02_0.OSCILLATOR_0.x6.XA7.CN a_21585_10695# 0.026f
C621 LELO_GR02_0.OSCILLATOR_0.x6.XA7.CN a_21585_11175# 0.02572f
C622 a_21585_11815# LELO_GR02_0.OSCILLATOR_0.x6.XA7.CN 0.06207f
C623 LELO_GR02_0.OSCILLATOR_0.x6.XA7.CN a_21585_9415# 0.04767f
C624 LELO_GR02_0.OSCILLATOR_0.x6.XA7.CN a_21585_9895# 0.08626f
C625 LELO_GR02_0.OSCILLATOR_0.x6.XA7.CN uo_out<0> 0.25685f
C626 LELO_GR02_0.OSCILLATOR_0.x6.XA7.MP1.S LELO_GR02_0.OSCILLATOR_0.x6.XA7.MN0.S 0.05173f
C627 LELO_GR02_0.OSCILLATOR_0.x6.XA7.MN0.S VGND 0.0979f
C628 LELO_GR02_0.OSCILLATOR_0.x6.XA7.MP1.S VDPWR 0.28519f
C629 LELO_GR02_0.OSCILLATOR_0.x6.XA7.MP1.S VGND 0.12129f
C630 LELO_GR02_0.OSCILLATOR_0.x6.XA7.MP1.S a_21585_11175# 0.0183f
C631 LELO_GR02_0.OSCILLATOR_0.x6.XA7.MP1.S uo_out<0> 0.08106f
C632 VDPWR VGND 0.31009p
C633 a_11030_9428# VDPWR 0.05235f
C634 a_17682_14315# VDPWR 0.045f
C635 a_17682_14700# VDPWR 0.47091f
C636 a_17682_15500# VDPWR 0.51211f
C637 a_18185_16201# VDPWR 0.63215f
C638 a_18185_16361# VDPWR 0.66337f
C639 a_18185_16841# VDPWR 0.65433f
C640 a_18185_17001# VDPWR 0.51722f
C641 a_18932_14314# VDPWR 0.04501f
C642 a_18932_14700# VDPWR 0.47166f
C643 a_18932_15500# VDPWR 0.51463f
C644 a_20567_12681# VDPWR 0.54311f
C645 a_20567_13481# VDPWR 0.53622f
C646 a_20745_12135# VDPWR 0.02304f
C647 a_21585_10375# VDPWR 0.30908f
C648 a_21585_10695# VDPWR 0.30912f
C649 a_21585_11175# VDPWR 0.29994f
C650 a_21585_11815# VDPWR 0.31129f
C651 a_21585_12135# VDPWR 0.29288f
C652 a_21585_8295# VDPWR 0.35757f
C653 a_21585_8615# VDPWR 0.40085f
C654 a_21585_9095# VDPWR 0.32808f
C655 a_21585_9415# VDPWR 0.31316f
C656 a_21585_9895# VDPWR 0.31321f
C657 a_28996_20830# VDPWR 0.36441f
C658 a_28996_21150# VDPWR 0.39912f
C659 a_28996_21470# VDPWR 0.28608f
C660 a_3635_9859# VDPWR 0.01678f
C661 a_3743_10332# VDPWR 0.69044f
C662 a_3743_11132# VDPWR 0.6712f
C663 a_3743_11266# VDPWR 0.6712f
C664 a_3743_12066# VDPWR 0.6712f
C665 a_3743_12200# VDPWR 0.6712f
C666 a_3743_13000# VDPWR 0.67397f
C667 a_3744_13136# VDPWR 0.67392f
C668 a_3744_13936# VDPWR 0.85892f
C669 a_5141_9860# VDPWR 0.0256f
C670 a_5506_10332# VDPWR 0.69122f
C671 a_5506_11132# VDPWR 0.67191f
C672 a_5506_11266# VDPWR 0.67191f
C673 a_5506_12066# VDPWR 0.67191f
C674 a_5506_12200# VDPWR 0.67191f
C675 a_5506_13000# VDPWR 0.67474f
C676 a_5507_13136# VDPWR 0.6747f
C677 a_5507_13936# VDPWR 0.87123f
C678 a_5664_14810# VDPWR 0.52758f
C679 a_5664_14970# VDPWR 0.65536f
C680 a_5664_15450# VDPWR 0.66844f
C681 a_5664_15610# VDPWR 0.66789f
C682 a_6392_9860# VDPWR 0.02853f
C683 a_7268_10332# VDPWR 0.69061f
C684 a_7268_11132# VDPWR 0.67199f
C685 a_7268_11266# VDPWR 0.67199f
C686 a_7268_12066# VDPWR 0.6717f
C687 a_7268_12200# VDPWR 0.67199f
C688 a_7268_13000# VDPWR 0.67453f
C689 a_7269_13136# VDPWR 0.67449f
C690 a_7269_13936# VDPWR 0.86266f
C691 a_7642_9858# VDPWR 0.01997f
C692 a_8598_17876# VDPWR 0.28368f
C693 a_8598_18196# VDPWR 0.28269f
C694 a_8598_18706# VDPWR 0.29586f
C695 a_8598_19026# VDPWR 0.34013f
C696 a_8748_14798# VDPWR 0.66319f
C697 a_8748_14958# VDPWR 0.66141f
C698 a_8748_15438# VDPWR 0.66783f
C699 a_8748_15598# VDPWR 0.65066f
C700 a_9590_10585# VDPWR 0.33489f
C701 a_9590_10745# VDPWR 0.35531f
C702 a_9590_11225# VDPWR 0.35583f
C703 a_9590_11385# VDPWR 0.36916f
C704 a_9590_11622# VDPWR 0.36887f
C705 a_9590_11782# VDPWR 0.35554f
C706 a_9590_12262# VDPWR 0.35583f
C707 a_9590_12422# VDPWR 0.36937f
C708 a_9590_12661# VDPWR 0.36937f
C709 a_9590_12821# VDPWR 0.35554f
C710 a_9590_13301# VDPWR 0.3559f
C711 a_9590_13461# VDPWR 0.37275f
C712 a_9590_13714# VDPWR 0.37281f
C713 a_9590_13874# VDPWR 0.35582f
C714 a_9590_14354# VDPWR 0.36753f
C715 a_9590_14514# VDPWR 0.52354f
C716 VDPWR ui_in<0> 2.16727f
C717 VDPWR uo_out<0> 6.63296f
C718 a_11030_9428# VGND 1.85094f $ **FLOATING
C719 a_11246_9428# VGND 0.52984f
C720 a_11462_11348# VGND 0.63171f
C721 a_11678_9428# VGND 0.43595f
C722 a_11894_11348# VGND 0.63171f
C723 a_12110_9428# VGND 0.43595f
C724 a_12326_11348# VGND 0.63171f
C725 a_12542_9428# VGND 0.52959f
C726 a_12974_9428# VGND 1.91723f $ **FLOATING
C727 a_15861_10426# VGND 0.65965f $ **FLOATING
C728 a_15861_10586# VGND 0.64474f $ **FLOATING
C729 a_15861_9786# VGND 0.82513f $ **FLOATING
C730 a_15861_9946# VGND 0.67455f $ **FLOATING
C731 a_16245_11265# VGND 0.43301f $ **FLOATING
C732 a_16245_12065# VGND 0.51338f $ **FLOATING
C733 a_16918_2966# VGND 1.89352f $ **FLOATING
C734 a_17134_2966# VGND 0.52984f
C735 a_17350_4886# VGND 0.63348f
C736 a_17426_6366# VGND 0.85695f $ **FLOATING
C737 a_17426_6526# VGND 0.67788f $ **FLOATING
C738 a_17426_7006# VGND 0.61738f $ **FLOATING
C739 a_17426_7122# VGND 0.68411f $ **FLOATING
C740 a_17426_7282# VGND 0.6175f $ **FLOATING
C741 a_17426_7762# VGND 0.66498f $ **FLOATING
C742 a_17426_7922# VGND 0.57543f $ **FLOATING
C743 a_17566_2966# VGND 0.43595f
C744 a_17682_10315# VGND 0.64184f $ **FLOATING
C745 a_17682_11115# VGND 0.4694f $ **FLOATING
C746 a_17682_11915# VGND 0.46862f $ **FLOATING
C747 a_17682_12715# VGND 0.46888f $ **FLOATING
C748 a_17682_13515# VGND 0.46888f $ **FLOATING
C749 a_17682_14315# VGND 0.46486f $ **FLOATING
C750 a_17682_14700# VGND 0.03446f $ **FLOATING
C751 a_17682_15500# VGND 0.05534f $ **FLOATING
C752 a_17682_8056# VGND 0.47635f $ **FLOATING
C753 a_17682_8856# VGND 0.72391f $ **FLOATING
C754 a_17782_4886# VGND 0.63171f
C755 a_17998_2966# VGND 0.43595f
C756 a_18185_16201# VGND 0.11015f $ **FLOATING
C757 a_18185_17001# VGND 0.14323f $ **FLOATING
C758 a_18214_4886# VGND 0.63171f
C759 a_18323_10035# VGND 0.69179f $ **FLOATING
C760 a_18323_9235# VGND 0.68074f $ **FLOATING
C761 a_18430_2966# VGND 0.43595f
C762 a_18646_4886# VGND 0.63171f
C763 a_18862_2966# VGND 0.43595f
C764 a_18932_10314# VGND 0.6341f $ **FLOATING
C765 a_18932_11114# VGND 0.46943f $ **FLOATING
C766 a_18932_11914# VGND 0.46939f $ **FLOATING
C767 a_18932_12714# VGND 0.46779f $ **FLOATING
C768 a_18932_13514# VGND 0.46779f $ **FLOATING
C769 a_18932_14314# VGND 0.46521f $ **FLOATING
C770 a_18932_14700# VGND 0.03452f $ **FLOATING
C771 a_18932_15500# VGND 0.05847f $ **FLOATING
C772 a_18932_6366# VGND 0.85789f $ **FLOATING
C773 a_18932_6526# VGND 0.67811f $ **FLOATING
C774 a_18932_7006# VGND 0.61724f $ **FLOATING
C775 a_18932_7122# VGND 0.68219f $ **FLOATING
C776 a_18932_7282# VGND 0.61636f $ **FLOATING
C777 a_18932_7762# VGND 0.66336f $ **FLOATING
C778 a_18932_7922# VGND 0.59671f $ **FLOATING
C779 a_18932_8056# VGND 0.47946f $ **FLOATING
C780 a_18932_8856# VGND 0.72875f $ **FLOATING
C781 a_19078_4886# VGND 0.63245f
C782 a_19294_2966# VGND 0.43595f
C783 a_19510_4886# VGND 0.63171f
C784 a_19726_2966# VGND 0.43595f
C785 a_19942_4886# VGND 0.63171f
C786 a_20158_2966# VGND 0.52984f
C787 a_20567_12681# VGND 0.09062f $ **FLOATING
C788 a_20567_13481# VGND 0.1113f $ **FLOATING
C789 a_20590_2966# VGND 1.93767f $ **FLOATING
C790 a_20745_10375# VGND 0.31123f $ **FLOATING
C791 a_20745_10695# VGND 0.31386f $ **FLOATING
C792 a_20745_11175# VGND 0.31656f $ **FLOATING
C793 a_20745_11815# VGND 0.31278f $ **FLOATING
C794 a_20745_12135# VGND 0.32242f $ **FLOATING
C795 a_20745_8295# VGND 0.47145f $ **FLOATING
C796 a_20745_8615# VGND 0.4038f $ **FLOATING
C797 a_20745_9095# VGND 0.3123f $ **FLOATING
C798 a_20745_9415# VGND 0.31468f $ **FLOATING
C799 a_20745_9895# VGND 0.31632f $ **FLOATING
C800 a_20984_6827# VGND 0.86456f $ **FLOATING
C801 a_20984_6987# VGND 0.67808f $ **FLOATING
C802 a_20984_7467# VGND 0.6707f $ **FLOATING
C803 a_20984_7627# VGND 0.74481f $ **FLOATING
C804 a_21585_12135# VGND 0.07623f $ **FLOATING
C805 a_21585_8295# VGND 0.09696f $ **FLOATING
C806 a_28156_20830# VGND 0.445f $ **FLOATING
C807 a_28156_21150# VGND 0.39995f $ **FLOATING
C808 a_28156_21470# VGND 0.3474f $ **FLOATING
C809 a_28996_20830# VGND 0.09847f $ **FLOATING
C810 a_28996_21470# VGND 0.08187f $ **FLOATING
C811 a_3635_9059# VGND 0.85427f $ **FLOATING
C812 a_3635_9219# VGND 0.68159f $ **FLOATING
C813 a_3635_9699# VGND 0.65891f $ **FLOATING
C814 a_3635_9859# VGND 0.60625f $ **FLOATING
C815 a_3743_10332# VGND 0.14019f $ **FLOATING
C816 a_3744_13936# VGND 0.17389f $ **FLOATING
C817 a_4521_7034# VGND 0.64764f $ **FLOATING
C818 a_4521_7834# VGND 0.49508f $ **FLOATING
C819 a_4521_7969# VGND 0.49506f $ **FLOATING
C820 a_4521_8769# VGND 0.64758f $ **FLOATING
C821 a_5141_9060# VGND 0.65516f $ **FLOATING
C822 a_5141_9860# VGND 0.49307f $ **FLOATING
C823 a_5195_3790# VGND 1.96546f $ **FLOATING
C824 a_5411_3790# VGND 0.55557f
C825 a_5506_10332# VGND 0.14028f $ **FLOATING
C826 a_5507_13936# VGND 0.15513f $ **FLOATING
C827 a_5627_5710# VGND 0.87873f
C828 a_5664_14810# VGND 0.11845f $ **FLOATING
C829 a_5664_15610# VGND 0.14323f $ **FLOATING
C830 a_5773_7035# VGND 0.6617f $ **FLOATING
C831 a_5773_7835# VGND 0.49532f $ **FLOATING
C832 a_5773_7970# VGND 0.4953f $ **FLOATING
C833 a_5773_8770# VGND 0.64105f $ **FLOATING
C834 a_5843_3790# VGND 0.83083f
C835 a_6059_5710# VGND 0.91196f
C836 a_6275_3790# VGND 0.46183f
C837 a_6392_9060# VGND 0.65614f $ **FLOATING
C838 a_6392_9860# VGND 0.49484f $ **FLOATING
C839 a_6491_5710# VGND 0.6444f
C840 a_6707_3790# VGND 0.53896f
C841 a_7023_7034# VGND 0.65189f $ **FLOATING
C842 a_7023_7834# VGND 0.4968f $ **FLOATING
C843 a_7023_7969# VGND 0.49679f $ **FLOATING
C844 a_7023_8769# VGND 0.64339f $ **FLOATING
C845 a_7139_3790# VGND 1.96444f $ **FLOATING
C846 a_7268_10332# VGND 0.14613f $ **FLOATING
C847 a_7269_13936# VGND 0.17022f $ **FLOATING
C848 a_7642_9058# VGND 0.84058f $ **FLOATING
C849 a_7642_9218# VGND 0.68243f $ **FLOATING
C850 a_7642_9698# VGND 0.6578f $ **FLOATING
C851 a_7642_9858# VGND 0.60803f $ **FLOATING
C852 a_7758_17876# VGND 0.36086f $ **FLOATING
C853 a_7758_18196# VGND 0.33645f $ **FLOATING
C854 a_7758_18706# VGND 0.41672f $ **FLOATING
C855 a_7758_19026# VGND 0.35929f $ **FLOATING
C856 a_8598_17876# VGND 0.08125f $ **FLOATING
C857 a_8598_18196# VGND 0.05561f $ **FLOATING
C858 a_8598_18706# VGND 0.05817f $ **FLOATING
C859 a_8598_19026# VGND 0.08883f $ **FLOATING
C860 a_8748_14798# VGND 0.05671f $ **FLOATING
C861 a_8748_15598# VGND 0.14323f $ **FLOATING
C862 a_9590_10585# VGND 0.09222f $ **FLOATING
C863 a_9590_14514# VGND 0.02677f $ **FLOATING
C864 clk VGND 0.04284f
C865 ena VGND 0.06659f
C866 m1_5524_9447# VGND 0.01479f $ **FLOATING
C867 m4_6134_21932# VGND 0.01451f $ **FLOATING
C868 m4_9998_21956# VGND 0.01451f $ **FLOATING
C869 rst_n VGND 0.04185f
C870 ui_in<0> VGND 7.696f
C871 ui_in<1> VGND 0.04152f
C872 ui_in<2> VGND 0.04228f
C873 ui_in<3> VGND 0.0423f
C874 ui_in<4> VGND 0.0423f
C875 ui_in<5> VGND 0.0423f
C876 ui_in<6> VGND 0.0423f
C877 ui_in<7> VGND 0.0423f
C878 uio_in<0> VGND 0.0423f
C879 uio_in<1> VGND 0.0423f
C880 uio_in<2> VGND 0.0423f
C881 uio_in<3> VGND 0.0423f
C882 uio_in<4> VGND 0.0423f
C883 uio_in<5> VGND 0.0423f
C884 uio_in<6> VGND 0.0423f
C885 uio_in<7> VGND 0.0423f
C886 uio_oe<0> VGND 0.05316f
C887 uio_oe<1> VGND 0.04356f
C888 uio_oe<2> VGND 0.04418f
C889 uio_oe<3> VGND 0.04293f
C890 uio_oe<4> VGND 0.04168f
C891 uio_oe<5> VGND 0.04418f
C892 uio_oe<6> VGND 0.04418f
C893 uio_oe<7> VGND 0.08647f
C894 uio_out<0> VGND 0.0423f
C895 uio_out<1> VGND 0.0423f
C896 uio_out<2> VGND 0.0423f
C897 uio_out<3> VGND 0.0423f
C898 uio_out<4> VGND 0.0423f
C899 uio_out<5> VGND 0.0423f
C900 uio_out<6> VGND 0.0423f
C901 uio_out<7> VGND 0.0423f
C902 uo_out<0> VGND 7.83174f
C903 uo_out<1> VGND 0.04181f
C904 uo_out<2> VGND 0.04198f
C905 uo_out<3> VGND 0.04198f
C906 uo_out<4> VGND 0.03352f
C907 uo_out<5> VGND 0.0423f
C908 uo_out<6> VGND 0.0423f
C909 uo_out<7> VGND 0.0423f
C910 a_11030_9428# a_11246_9428# 0.01515f
C911 a_11246_9428# a_11678_9428# 0.14233f
C912 a_11462_11348# a_11894_11348# 0.21349f
C913 a_11678_9428# a_12110_9428# 0.14233f
C914 a_11894_11348# a_12326_11348# 0.21349f
C915 a_12110_9428# a_12542_9428# 0.14233f
C916 a_12542_9428# a_12974_9428# 0.01515f
C917 a_15861_10586# a_15861_10426# 0.15007f
C918 a_15861_10426# a_15861_9946# 0.02114f
C919 a_16245_11265# a_15861_10586# 0.01774f
C920 a_15861_9946# a_15861_9786# 0.15007f
C921 a_16918_2966# a_17134_2966# 0.01515f
C922 a_17134_2966# a_17566_2966# 0.14233f
C923 a_17350_4886# a_17782_4886# 0.21349f
C924 a_17426_6526# a_17426_6366# 0.15007f
C925 a_17426_7006# a_17426_6526# 0.02114f
C926 a_17426_7122# a_17426_7006# 0.24178f
C927 a_17426_7282# a_17426_7122# 0.24178f
C928 a_17426_7762# a_17426_7282# 0.02114f
C929 a_17426_7922# a_17426_7762# 0.15007f
C930 a_17682_8056# a_17426_7922# 0.14791f
C931 a_17566_2966# a_17998_2966# 0.14233f
C932 a_17682_14700# a_17682_14315# 0.03904f
C933 a_17782_4886# a_18214_4886# 0.21349f
C934 a_17998_2966# a_18430_2966# 0.14233f
C935 a_18185_16361# a_18185_16201# 0.15007f
C936 a_18185_16841# a_18185_16361# 0.02114f
C937 a_18185_17001# a_18185_16841# 0.15007f
C938 a_18214_4886# a_18646_4886# 0.21349f
C939 a_18932_10314# a_18323_10035# 0.01518f
C940 a_18430_2966# a_18862_2966# 0.14233f
C941 a_18646_4886# a_19078_4886# 0.21349f
C942 a_18862_2966# a_19294_2966# 0.14233f
C943 a_18932_14700# a_18932_14314# 0.03892f
C944 a_18932_6526# a_18932_6366# 0.15007f
C945 a_18932_7006# a_18932_6526# 0.02114f
C946 a_18932_7122# a_18932_7006# 0.24178f
C947 a_18932_7282# a_18932_7122# 0.24178f
C948 a_18932_7762# a_18932_7282# 0.02114f
C949 a_18932_7922# a_18932_7762# 0.15007f
C950 a_18932_8056# a_18932_7922# 0.12516f
C951 a_19078_4886# a_19510_4886# 0.21349f
C952 a_19294_2966# a_19726_2966# 0.14233f
C953 a_19510_4886# a_19942_4886# 0.21349f
C954 a_19726_2966# a_20158_2966# 0.14233f
C955 a_20158_2966# a_20590_2966# 0.01515f
C956 a_20567_12681# a_20745_12135# 0.01868f
C957 a_20745_10695# a_20745_10375# 0.01f
C958 a_20745_12135# a_20745_11815# 0.01f
C959 a_20745_12135# uo_out<0> 0.01858f
C960 a_20745_8615# a_20745_8295# 0.01f
C961 a_20745_9415# a_20745_9095# 0.01f
C962 a_20984_6987# a_20984_6827# 0.15007f
C963 a_20984_7467# a_20984_6987# 0.02114f
C964 a_20984_7627# a_20984_7467# 0.15007f
C965 a_21585_8295# a_20984_7627# 0.01249f
C966 a_21585_10695# a_21585_10375# 0.01f
C967 a_21585_12135# a_21585_11815# 0.01f
C968 a_21585_11815# uo_out<0> 0.02068f
C969 a_21585_12135# uo_out<0> 0.05052f
C970 a_21585_8615# a_21585_8295# 0.01f
C971 a_21585_9415# a_21585_9095# 0.01f
C972 a_28156_21150# a_28156_20830# 0.01f
C973 a_28156_21470# a_28156_21150# 0.01f
C974 a_28996_21150# a_28996_20830# 0.01f
C975 a_28996_21470# a_28996_21150# 0.01f
C976 a_3635_9219# a_3635_9059# 0.15007f
C977 a_3635_9699# a_3635_9219# 0.02114f
C978 a_3635_9859# a_3635_9699# 0.15007f
C979 a_3743_10332# a_3635_9859# 0.03655f
C980 a_3743_11132# a_3743_10332# 0.01761f
C981 a_3743_11266# a_3743_11132# 0.23893f
C982 a_3743_12066# a_3743_11266# 0.01761f
C983 a_3743_12200# a_3743_12066# 0.23893f
C984 a_3743_13000# a_3743_12200# 0.01761f
C985 a_3744_13136# a_3743_13000# 0.23356f
C986 a_3744_13936# a_3744_13136# 0.01761f
C987 a_4521_7969# a_4521_7834# 0.14629f
C988 a_5141_9060# a_4521_8769# 0.01373f
C989 a_5506_10332# a_5141_9860# 0.01746f
C990 a_5195_3790# a_5411_3790# 0.01515f
C991 a_5411_3790# a_5843_3790# 0.14233f
C992 a_5506_11132# a_5506_10332# 0.01761f
C993 a_5506_11266# a_5506_11132# 0.23893f
C994 a_5506_12066# a_5506_11266# 0.01761f
C995 a_5506_12200# a_5506_12066# 0.23893f
C996 a_5506_13000# a_5506_12200# 0.01761f
C997 a_5507_13136# a_5506_13000# 0.23356f
C998 a_5507_13936# a_5507_13136# 0.01761f
C999 a_5664_14810# a_5507_13936# 0.01049f
C1000 a_5627_5710# a_6059_5710# 0.21349f
C1001 a_5664_14970# a_5664_14810# 0.15007f
C1002 a_5664_15450# a_5664_14970# 0.02114f
C1003 a_5664_15610# a_5664_15450# 0.15007f
C1004 a_5773_7970# a_5773_7835# 0.14629f
C1005 a_6392_9060# a_5773_8770# 0.01385f
C1006 a_5843_3790# a_6275_3790# 0.14233f
C1007 a_6059_5710# a_6491_5710# 0.21349f
C1008 a_6275_3790# a_6707_3790# 0.14233f
C1009 a_6707_3790# a_7139_3790# 0.01515f
C1010 a_7023_7969# a_7023_7834# 0.14629f
C1011 a_7642_9058# a_7023_8769# 0.01391f
C1012 a_7268_11132# a_7268_10332# 0.01761f
C1013 a_7268_10332# a_7642_9858# 0.02737f
C1014 a_7268_11266# a_7268_11132# 0.23893f
C1015 a_7268_12066# a_7268_11266# 0.01761f
C1016 a_7268_12200# a_7268_12066# 0.23893f
C1017 a_7268_13000# a_7268_12200# 0.01761f
C1018 a_7269_13136# a_7268_13000# 0.23356f
C1019 a_7269_13936# a_7269_13136# 0.01761f
C1020 a_7642_9218# a_7642_9058# 0.15007f
C1021 a_7642_9698# a_7642_9218# 0.02114f
C1022 a_7642_9858# a_7642_9698# 0.15007f
C1023 a_7758_18196# a_7758_17876# 0.01f
C1024 a_7758_18706# a_7758_18196# 0.02008f
C1025 a_7758_19026# a_7758_18706# 0.01f
C1026 a_7758_18706# ui_in<0> 0.06092f
C1027 a_7758_19026# ui_in<0> 0.11365f
C1028 a_8598_18196# a_8598_17876# 0.01f
C1029 a_8598_18706# a_8598_18196# 0.02008f
C1030 a_8598_19026# a_8598_18706# 0.01f
C1031 a_8598_18706# ui_in<0> 0.06129f
C1032 a_8598_19026# ui_in<0> 0.06192f
C1033 a_8748_14958# a_8748_14798# 0.15007f
C1034 a_8748_15438# a_8748_14958# 0.02114f
C1035 a_8748_15598# a_8748_15438# 0.15007f
C1036 a_9590_10745# a_9590_10585# 0.0971f
C1037 a_9590_11385# a_9590_11225# 0.0971f
C1038 a_9590_11622# a_9590_11385# 0.05836f
C1039 a_9590_11782# a_9590_11622# 0.0971f
C1040 a_9590_12422# a_9590_12262# 0.0971f
C1041 a_9590_12661# a_9590_12422# 0.05776f
C1042 a_9590_12821# a_9590_12661# 0.0971f
C1043 a_9590_13461# a_9590_13301# 0.0971f
C1044 a_9590_13714# a_9590_13461# 0.05389f
C1045 a_9590_13874# a_9590_13714# 0.0971f
C1046 a_9590_14514# a_9590_14354# 0.0971f
C1047 clk ena 0.03102f
C1048 rst_n clk 0.03102f
C1049 ui_in<0> rst_n 0.03102f
C1050 ui_in<0> ui_in<1> 0.03354f
C1051 ui_in<0> uo_out<0> 0.40043f
C1052 ui_in<2> ui_in<1> 0.03102f
C1053 ui_in<3> ui_in<2> 0.03102f
C1054 ui_in<4> ui_in<3> 0.03102f
C1055 ui_in<5> ui_in<4> 0.03102f
C1056 ui_in<6> ui_in<5> 0.03102f
C1057 ui_in<7> ui_in<6> 0.03102f
C1058 uio_in<0> ui_in<7> 0.03102f
C1059 uio_in<1> uio_in<0> 0.03102f
C1060 uio_in<2> uio_in<1> 0.03102f
C1061 uio_in<3> uio_in<2> 0.03102f
C1062 uio_in<4> uio_in<3> 0.03102f
C1063 uio_in<5> uio_in<4> 0.03102f
C1064 uio_in<6> uio_in<5> 0.03102f
C1065 uio_in<7> uio_in<6> 0.03102f
C1066 uo_out<0> uio_in<7> 0.03102f
C1067 uio_oe<1> uio_oe<0> 0.04467f
C1068 uio_oe<0> uio_out<7> 0.03102f
C1069 uio_oe<2> uio_oe<1> 0.0484f
C1070 uio_oe<3> uio_oe<2> 0.04747f
C1071 uio_oe<4> uio_oe<3> 0.0456f
C1072 uio_oe<5> uio_oe<4> 0.0456f
C1073 uio_oe<6> uio_oe<5> 0.04933f
C1074 uio_oe<7> uio_oe<6> 0.0484f
C1075 uio_out<1> uio_out<0> 0.03102f
C1076 uio_out<0> uo_out<7> 0.03102f
C1077 uio_out<2> uio_out<1> 0.03102f
C1078 uio_out<3> uio_out<2> 0.03102f
C1079 uio_out<4> uio_out<3> 0.03102f
C1080 uio_out<5> uio_out<4> 0.03102f
C1081 uio_out<6> uio_out<5> 0.03102f
C1082 uio_out<7> uio_out<6> 0.03102f
C1083 uo_out<0> uo_out<1> 0.03215f
C1084 uo_out<0> uo_out<4> 0.01223f
C1085 uo_out<2> uo_out<1> 0.03102f
C1086 uo_out<3> uo_out<2> 0.03102f
C1087 uo_out<4> uo_out<3> 0.03102f
C1088 uo_out<5> uo_out<4> 0.03102f
C1089 uo_out<6> uo_out<5> 0.03102f
C1090 uo_out<7> uo_out<6> 0.03102f
.ends
