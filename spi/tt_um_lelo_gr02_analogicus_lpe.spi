* NGSPICE file created from tt_um_lelo_gr02_analogicus.ext - technology: sky130A

* Replacing the lpe port list (../tech/scripts/fixlpe)
.subckt tt_um_lelo_gr02_analogicus uo_out<7> uo_out<6> uo_out<5> uo_out<4> uo_out<3> uo_out<2> uo_out<1> uo_out<0>
+ uio_out<7> uio_out<6> uio_out<5> uio_out<4> uio_out<3> uio_out<2> uio_out<1> uio_out<0> uio_oe<7> uio_oe<6> uio_oe<5> uio_oe<4> uio_oe<3> uio_oe<2> uio_oe<1> uio_oe<0> VDPWR VGND
+ ui_in<7> ui_in<6> ui_in<5> ui_in<4> ui_in<3> ui_in<2> ui_in<1> ui_in<0> uio_in<7> uio_in<6> uio_in<5> uio_in<4> uio_in<3> uio_in<2> uio_in<1> uio_in<0> ena rst_n clk
*.subckt tt_um_lelo_gr02_analogicus uo_out<7> uo_out<6> uo_out<5> uo_out<4> uo_out<3>
*+ uo_out<2> uo_out<1> uo_out<0> uio_out<7> uio_out<6> uio_out<5> uio_out<4> uio_out<3>
*+ uio_out<2> uio_out<1> uio_out<0> uio_oe<7> uio_oe<6> uio_oe<5> uio_oe<4> uio_oe<3>
*+ uio_oe<2> uio_oe<1> uio_oe<0> VDPWR VGND ui_in<7> ui_in<6> ui_in<5> ui_in<4> ui_in<3>
*+ ui_in<2> ui_in<1> ui_in<0> uio_in<7> uio_in<6> uio_in<5> uio_in<4> uio_in<3> uio_in<2>
*+ uio_in<1> uio_in<0> ena rst_n clk
X0 LELO_GR02_0.OSCILLATOR_0.x5.x11.G LELO_GR02_0.OSCILLATOR_0.V_CTAT LELO_GR02_0.OSCILLATOR_0.x5.x9<4>.S VGND sky130_fd_pr__nfet_01v8 ad=0.528 pd=2.26 as=0.848 ps=4.26 w=1.6 l=0.94
X1 LELO_GR02_0.BANDGAP_0.x5.B LELO_GR02_0.BANDGAP_0.x5.A sky130_fd_pr__cap_mim_m3_1 l=5 w=5
X2 LELO_GR02_0.OSCILLATOR_0.PWRUP_N_1V8 ui_in<0> VDPWR VDPWR sky130_fd_pr__pfet_01v8 ad=0.468 pd=2.84 as=0.468 ps=2.84 w=0.9 l=0.16
X3 LELO_GR02_0.BANDGAP_0.x2.LELOATR_PCH_12C5F0_7.G LELO_GR02_0.BANDGAP_0.x2.LELOATR_PCH_12C5F0_7.G LELO_GR02_0.BANDGAP_0.x2.x2.P VDPWR sky130_fd_pr__pfet_01v8 ad=1.3728 pd=4.82 as=2.2048 ps=9.38 w=4.16 l=0.94
X4 LELO_GR02_0.BANDGAP_0.x2.x2.P LELO_GR02_0.BANDGAP_0.x2.LELOATR_PCH_12C5F0_7.G LELO_GR02_0.BANDGAP_0.x2.x2<1>.A VDPWR sky130_fd_pr__pfet_01v8 ad=2.2048 pd=9.38 as=1.3728 ps=4.82 w=4.16 l=0.94
X5 LELO_GR02_0.OSCILLATOR_0.x13<2>.B LELO_GR02_0.OSCILLATOR_0.x6.CK LELO_GR02_0.OSCILLATOR_0.I_PTAT VGND sky130_fd_pr__nfet_01v8 ad=0.3168 pd=1.62 as=0.5088 ps=2.98 w=0.96 l=0.94
X6 LELO_GR02_0.OSCILLATOR_0.x5.x9<4>.D LELO_GR02_0.OSCILLATOR_0.I_PTAT LELO_GR02_0.OSCILLATOR_0.x5.x9<4>.S VGND sky130_fd_pr__nfet_01v8 ad=0.528 pd=2.26 as=0.848 ps=4.26 w=1.6 l=0.94
X7 VGND LELO_GR02_0.BANDGAP_0.x2.x6.D LELO_GR02_0.BANDGAP_0.x5.B VGND sky130_fd_pr__nfet_01v8 ad=0.848 pd=4.26 as=0.528 ps=2.26 w=1.6 l=0.94
X8 LELO_GR02_0.OSCILLATOR_0.PWRUP_B_1V8 LELO_GR02_0.OSCILLATOR_0.PWRUP_N_1V8 VGND VGND sky130_fd_pr__nfet_01v8 ad=0.468 pd=2.84 as=0.468 ps=2.84 w=0.9 l=0.16
X9 LELO_GR02_0.OSCILLATOR_0.x5.x11.S LELO_GR02_0.OSCILLATOR_0.x5.x11.G LELO_GR02_0.OSCILLATOR_0.x5.x9<4>.D VDPWR sky130_fd_pr__pfet_01v8 ad=0.848 pd=4.26 as=0.528 ps=2.26 w=1.6 l=0.94
X10 LELO_GR02_0.OSCILLATOR_0.x6.D LELO_GR02_0.OSCILLATOR_0.x6.XA7.CN LELO_GR02_0.OSCILLATOR_0.x6.XA6.MN1.S VGND sky130_fd_pr__nfet_01v8 ad=0.468 pd=2.84 as=0.288 ps=1.54 w=0.9 l=0.16
X11 LELO_GR02_0.BANDGAP_0.x2.LELOATR_NCH_4C5F0_5.D LELO_GR02_0.BANDGAP_0.x2.x6.D VGND VGND sky130_fd_pr__nfet_01v8 ad=0.528 pd=2.26 as=0.848 ps=4.26 w=1.6 l=0.94
X12 LELO_GR02_0.OSCILLATOR_0.x5.x11.S LELO_GR02_0.OSCILLATOR_0.PWRUP_N_1V8 VDPWR VDPWR sky130_fd_pr__pfet_01v8 ad=0.8352 pd=3.46 as=1.4112 ps=6.74 w=2.88 l=0.22
X13 LELO_GR02_0.BANDGAP_0.x5.A LELO_GR02_0.BANDGAP_0.x5.B LELO_GR02_0.OSCILLATOR_0.I_PTAT VDPWR sky130_fd_pr__pfet_01v8 ad=0.4704 pd=2.9 as=0.2784 ps=1.54 w=0.96 l=0.22
X14 LELO_GR02_0.OSCILLATOR_0.x6.XA7.C LELO_GR02_0.OSCILLATOR_0.x6.CK VDPWR VDPWR sky130_fd_pr__pfet_01v8 ad=0.288 pd=1.54 as=0.468 ps=2.84 w=0.9 l=0.16
X15 LELO_GR02_0.OSCILLATOR_0.x5.x11.G LELO_GR02_0.OSCILLATOR_0.x5.x11.G LELO_GR02_0.OSCILLATOR_0.x5.x11.S VDPWR sky130_fd_pr__pfet_01v8 ad=0.528 pd=2.26 as=0.848 ps=4.26 w=1.6 l=0.94
X16 LELO_GR02_0.OSCILLATOR_0.x13<2>.B LELO_GR02_0.OSCILLATOR_0.I_PTAT sky130_fd_pr__cap_mim_m3_1 l=5 w=5
R0 uio_oe<2> JNWTR_TIEL_CV_0.Y sky130_fd_pr__res_generic_m4 w=0.3 l=0.3
X17 LELO_GR02_0.OSCILLATOR_0.x13<2>.B LELO_GR02_0.OSCILLATOR_0.I_PTAT sky130_fd_pr__cap_mim_m3_1 l=5 w=5
X18 LELO_GR02_0.BANDGAP_0.x2.x2.P LELO_GR02_0.BANDGAP_0.x2.LELOATR_PCH_12C5F0_7.G LELO_GR02_0.BANDGAP_0.x2.LELOATR_PCH_12C5F0_7.G VDPWR sky130_fd_pr__pfet_01v8 ad=2.2048 pd=9.38 as=1.3728 ps=4.82 w=4.16 l=0.94
X19 LELO_GR02_0.BANDGAP_0.x5.B LELO_GR02_0.BANDGAP_0.x2.x2<1>.A LELO_GR02_0.BANDGAP_0.x2.x2.P VDPWR sky130_fd_pr__pfet_01v8 ad=1.3728 pd=4.82 as=2.2048 ps=9.38 w=4.16 l=0.94
X20 VGND LELO_GR02_0.BANDGAP_0.x2.x6.D LELO_GR02_0.BANDGAP_0.x5.B VGND sky130_fd_pr__nfet_01v8 ad=0.848 pd=4.26 as=0.528 ps=2.26 w=1.6 l=0.94
X21 LELO_GR02_0.BANDGAP_0.x5.B LELO_GR02_0.BANDGAP_0.x2.x2<1>.A sky130_fd_pr__cap_mim_m3_1 l=5 w=5
X22 LELO_GR02_0.BANDGAP_0.x2.x2.P LELO_GR02_0.OSCILLATOR_0.PWRUP_N_1V8 VDPWR VDPWR sky130_fd_pr__pfet_01v8 ad=0.8352 pd=3.46 as=1.4112 ps=6.74 w=2.88 l=0.22
X23 VGND LELO_GR02_0.OSCILLATOR_0.PWRUP_B_1V8 LELO_GR02_0.OSCILLATOR_0.x13<2>.B VGND sky130_fd_pr__nfet_01v8 ad=1.4112 pd=6.74 as=0.8352 ps=3.46 w=2.88 l=0.22
X24 LELO_GR02_0.BANDGAP_0.x2.x2.P LELO_GR02_0.BANDGAP_0.x2.x2<1>.A LELO_GR02_0.BANDGAP_0.x5.B VDPWR sky130_fd_pr__pfet_01v8 ad=2.2048 pd=9.38 as=1.3728 ps=4.82 w=4.16 l=0.94
X25 LELO_GR02_0.BANDGAP_0.x5.B LELO_GR02_0.BANDGAP_0.x2.x2<1>.A sky130_fd_pr__cap_mim_m3_1 l=5 w=5
X26 LELO_GR02_0.OSCILLATOR_0.x5.x9<4>.S LELO_GR02_0.OSCILLATOR_0.V_CTAT LELO_GR02_0.OSCILLATOR_0.x5.x11.G VGND sky130_fd_pr__nfet_01v8 ad=0.848 pd=4.26 as=0.528 ps=2.26 w=1.6 l=0.94
X27 LELO_GR02_0.BANDGAP_0.x2.x2.P a_6707_3790# VGND sky130_fd_pr__res_high_po w=0.36 l=7.36
X28 LELO_GR02_0.BANDGAP_0.x2.x2<1>.A LELO_GR02_0.BANDGAP_0.x2.LELOATR_PCH_12C5F0_7.G LELO_GR02_0.BANDGAP_0.x2.x2.P VDPWR sky130_fd_pr__pfet_01v8 ad=1.3728 pd=4.82 as=2.2048 ps=9.38 w=4.16 l=0.94
X29 LELO_GR02_0.OSCILLATOR_0.x5.x9<4>.D LELO_GR02_0.OSCILLATOR_0.I_PTAT LELO_GR02_0.OSCILLATOR_0.x5.x9<4>.S VGND sky130_fd_pr__nfet_01v8 ad=0.528 pd=2.26 as=0.848 ps=4.26 w=1.6 l=0.94
X30 LELO_GR02_0.OSCILLATOR_0.x13<2>.B LELO_GR02_0.OSCILLATOR_0.I_PTAT sky130_fd_pr__cap_mim_m3_1 l=5 w=5
X31 LELO_GR02_0.BANDGAP_0.x2.x6.D LELO_GR02_0.BANDGAP_0.x2.x6.D VGND VGND sky130_fd_pr__nfet_01v8 ad=0.528 pd=2.26 as=0.848 ps=4.26 w=1.6 l=0.94
X32 LELO_GR02_0.OSCILLATOR_0.I_PTAT LELO_GR02_0.BANDGAP_0.x5.B LELO_GR02_0.BANDGAP_0.x5.A VDPWR sky130_fd_pr__pfet_01v8 ad=0.2784 pd=1.54 as=0.4704 ps=2.9 w=0.96 l=0.22
X33 LELO_GR02_0.OSCILLATOR_0.x5.x7.G LELO_GR02_0.OSCILLATOR_0.PWRUP_N_1V8 VGND VGND sky130_fd_pr__nfet_01v8 ad=0.8352 pd=3.46 as=1.4112 ps=6.74 w=2.88 l=0.22
X34 LELO_GR02_0.BANDGAP_0.x2.LELOATR_PCH_12C5F0_7.G LELO_GR02_0.BANDGAP_0.x2.LELOATR_PCH_12C5F0_7.G LELO_GR02_0.BANDGAP_0.x2.x2.P VDPWR sky130_fd_pr__pfet_01v8 ad=1.3728 pd=4.82 as=2.2048 ps=9.38 w=4.16 l=0.94
X35 LELO_GR02_0.BANDGAP_0.x5.B LELO_GR02_0.BANDGAP_0.x2.x2<1>.A sky130_fd_pr__cap_mim_m3_1 l=5 w=5
X36 LELO_GR02_0.OSCILLATOR_0.x6.XA7.CN LELO_GR02_0.OSCILLATOR_0.x6.XA7.C VDPWR VDPWR sky130_fd_pr__pfet_01v8 ad=0.468 pd=2.84 as=0.468 ps=2.84 w=0.9 l=0.16
X37 VGND VGND LELO_GR02_0.BANDGAP_0.x8.DN sky130_fd_pr__pnp_05v5_W3p40L3p40
**devattr s=462400,2720
X38 LELO_GR02_0.OSCILLATOR_0.x13<2>.B LELO_GR02_0.OSCILLATOR_0.I_PTAT sky130_fd_pr__cap_mim_m3_1 l=5 w=5
X39 a_19510_4886# a_19294_2966# VGND sky130_fd_pr__res_high_po w=0.36 l=7.36
X40 VGND VGND VGND VGND sky130_fd_pr__nfet_01v8 ad=0.468 pd=2.84 as=102.5352 ps=547.52002 w=0.9 l=0.16
X41 LELO_GR02_0.BANDGAP_0.x2.x2<1>.A LELO_GR02_0.BANDGAP_0.x4.D LELO_GR02_0.BANDGAP_0.x2.LELOATR_NCH_4C5F0_5.D VGND sky130_fd_pr__nfet_01v8 ad=0.528 pd=2.26 as=0.848 ps=4.26 w=1.6 l=0.94
R1 uio_oe<3> JNWTR_TIEL_CV_0.Y sky130_fd_pr__res_generic_m4 w=0.3 l=0.3
X42 LELO_GR02_0.OSCILLATOR_0.x6.CK LELO_GR02_0.OSCILLATOR_0.PWRUP_N_1V8 VGND VGND sky130_fd_pr__nfet_01v8 ad=0.8352 pd=3.46 as=1.4112 ps=6.74 w=2.88 l=0.22
X43 a_6491_5710# a_6707_3790# VGND sky130_fd_pr__res_high_po w=0.36 l=7.36
X44 LELO_GR02_0.BANDGAP_0.x2.x6.D LELO_GR02_0.BANDGAP_0.x2.x6.D VGND VGND sky130_fd_pr__nfet_01v8 ad=0.528 pd=2.26 as=0.848 ps=4.26 w=1.6 l=0.94
X45 LELO_GR02_0.OSCILLATOR_0.x13<2>.B LELO_GR02_0.OSCILLATOR_0.I_PTAT sky130_fd_pr__cap_mim_m3_1 l=5 w=5
X46 LELO_GR02_0.OSCILLATOR_0.x13<2>.B LELO_GR02_0.OSCILLATOR_0.I_PTAT sky130_fd_pr__cap_mim_m3_1 l=5 w=5
X47 LELO_GR02_0.OSCILLATOR_0.x6.XA4.MP1.S LELO_GR02_0.OSCILLATOR_0.x6.XA6.A VDPWR VDPWR sky130_fd_pr__pfet_01v8 ad=0.288 pd=1.54 as=0.468 ps=2.84 w=0.9 l=0.16
X48 LELO_GR02_0.BANDGAP_0.x2.LELOATR_NCH_4C5F0_5.D LELO_GR02_0.OSCILLATOR_0.V_CTAT LELO_GR02_0.BANDGAP_0.x2.LELOATR_PCH_12C5F0_7.G VGND sky130_fd_pr__nfet_01v8 ad=0.848 pd=4.26 as=0.528 ps=2.26 w=1.6 l=0.94
X49 LELO_GR02_0.BANDGAP_0.x4.D a_12542_9428# VGND sky130_fd_pr__res_high_po w=0.36 l=7.36
X50 LELO_GR02_0.OSCILLATOR_0.x6.XA3.MN1.S LELO_GR02_0.OSCILLATOR_0.x6.D VGND VGND sky130_fd_pr__nfet_01v8 ad=0.288 pd=1.54 as=0.468 ps=2.84 w=0.9 l=0.16
X51 LELO_GR02_0.OSCILLATOR_0.x6.XA5.A LELO_GR02_0.OSCILLATOR_0.x6.XA7.CN LELO_GR02_0.OSCILLATOR_0.x6.XA3.MP1.S VDPWR sky130_fd_pr__pfet_01v8 ad=0.468 pd=2.84 as=0.288 ps=1.54 w=0.9 l=0.16
X52 LELO_GR02_0.OSCILLATOR_0.x13<2>.B LELO_GR02_0.OSCILLATOR_0.PWRUP_B_1V8 VGND VGND sky130_fd_pr__nfet_01v8 ad=0.8352 pd=3.46 as=1.4112 ps=6.74 w=2.88 l=0.22
X53 LELO_GR02_0.OSCILLATOR_0.x5.x9<4>.S LELO_GR02_0.OSCILLATOR_0.I_PTAT LELO_GR02_0.OSCILLATOR_0.x5.x9<4>.D VGND sky130_fd_pr__nfet_01v8 ad=0.848 pd=4.26 as=0.528 ps=2.26 w=1.6 l=0.94
R2 uio_oe<1> JNWTR_TIEL_CV_0.Y sky130_fd_pr__res_generic_m4 w=0.3 l=0.3
X54 LELO_GR02_0.BANDGAP_0.x2.x6.D a_5411_3790# VGND sky130_fd_pr__res_high_po w=0.36 l=7.36
X55 VGND VGND VGND VGND sky130_fd_pr__nfet_01v8 ad=0.468 pd=2.84 as=0 ps=0 w=0.9 l=0.16
X56 LELO_GR02_0.BANDGAP_0.x2.x2.P LELO_GR02_0.BANDGAP_0.x2.x2<1>.A LELO_GR02_0.BANDGAP_0.x5.B VDPWR sky130_fd_pr__pfet_01v8 ad=2.2048 pd=9.38 as=1.3728 ps=4.82 w=4.16 l=0.94
X57 VGND LELO_GR02_0.OSCILLATOR_0.PWRUP_N_1V8 LELO_GR02_0.OSCILLATOR_0.x6.CK VGND sky130_fd_pr__nfet_01v8 ad=1.4112 pd=6.74 as=0.8352 ps=3.46 w=2.88 l=0.22
X58 LELO_GR02_0.OSCILLATOR_0.x6.XA7.C LELO_GR02_0.OSCILLATOR_0.PWRUP_B_1V8 LELO_GR02_0.OSCILLATOR_0.x6.XA1.MN1.S VGND sky130_fd_pr__nfet_01v8 ad=0.468 pd=2.84 as=0.288 ps=1.54 w=0.9 l=0.16
X59 LELO_GR02_0.OSCILLATOR_0.x5.x7.G LELO_GR02_0.OSCILLATOR_0.x5.x7.G VGND VGND sky130_fd_pr__nfet_01v8 ad=0.528 pd=2.26 as=0.848 ps=4.26 w=1.6 l=0.94
X60 LELO_GR02_0.OSCILLATOR_0.I_PTAT LELO_GR02_0.BANDGAP_0.x5.B LELO_GR02_0.BANDGAP_0.x5.A VDPWR sky130_fd_pr__pfet_01v8 ad=0.2784 pd=1.54 as=0.4704 ps=2.9 w=0.96 l=0.22
X61 a_17782_4886# a_17566_2966# VGND sky130_fd_pr__res_high_po w=0.36 l=7.36
X62 LELO_GR02_0.OSCILLATOR_0.x6.CK LELO_GR02_0.OSCILLATOR_0.x5.x9<4>.D LELO_GR02_0.OSCILLATOR_0.x5.x11.S VDPWR sky130_fd_pr__pfet_01v8_lvt ad=0.528 pd=2.26 as=0.848 ps=4.26 w=1.6 l=0.94
X63 LELO_GR02_0.BANDGAP_0.x2.x2<1>.A LELO_GR02_0.BANDGAP_0.x2.LELOATR_PCH_12C5F0_7.G LELO_GR02_0.BANDGAP_0.x2.x2.P VDPWR sky130_fd_pr__pfet_01v8 ad=1.3728 pd=4.82 as=2.2048 ps=9.38 w=4.16 l=0.94
X64 LELO_GR02_0.BANDGAP_0.x5.B LELO_GR02_0.OSCILLATOR_0.PWRUP_N_1V8 VGND VGND sky130_fd_pr__nfet_01v8 ad=0.8352 pd=3.46 as=1.4112 ps=6.74 w=2.88 l=0.22
X65 LELO_GR02_0.OSCILLATOR_0.x5.x9<4>.S LELO_GR02_0.OSCILLATOR_0.V_CTAT LELO_GR02_0.OSCILLATOR_0.x5.x11.G VGND sky130_fd_pr__nfet_01v8 ad=0.848 pd=4.26 as=0.528 ps=2.26 w=1.6 l=0.94
R3 uio_oe<7> JNWTR_TIEL_CV_0.Y sky130_fd_pr__res_generic_m4 w=0.3 l=0.3
X66 a_11462_11348# a_11246_9428# VGND sky130_fd_pr__res_high_po w=0.36 l=7.36
X67 VDPWR LELO_GR02_0.OSCILLATOR_0.PWRUP_N_1V8 LELO_GR02_0.BANDGAP_0.x5.A VDPWR sky130_fd_pr__pfet_01v8 ad=1.4112 pd=6.74 as=0.8352 ps=3.46 w=2.88 l=0.22
X68 LELO_GR02_0.OSCILLATOR_0.x6.XA6.A LELO_GR02_0.OSCILLATOR_0.x6.XA5.A VDPWR VDPWR sky130_fd_pr__pfet_01v8 ad=0.468 pd=2.84 as=0.468 ps=2.84 w=0.9 l=0.16
X69 LELO_GR02_0.OSCILLATOR_0.x5.x9<4>.S LELO_GR02_0.OSCILLATOR_0.x5.x7.G VGND VGND sky130_fd_pr__nfet_01v8 ad=0.528 pd=2.26 as=0.848 ps=4.26 w=1.6 l=0.94
R4 uio_oe<6> JNWTR_TIEL_CV_0.Y sky130_fd_pr__res_generic_m4 w=0.3 l=0.3
X70 VGND LELO_GR02_0.OSCILLATOR_0.PWRUP_N_1V8 LELO_GR02_0.OSCILLATOR_0.x5.x7.G VGND sky130_fd_pr__nfet_01v8 ad=1.4112 pd=6.74 as=0.8352 ps=3.46 w=2.88 l=0.22
X71 LELO_GR02_0.OSCILLATOR_0.x5.x11.G LELO_GR02_0.OSCILLATOR_0.V_CTAT LELO_GR02_0.OSCILLATOR_0.x5.x9<4>.S VGND sky130_fd_pr__nfet_01v8 ad=0.528 pd=2.26 as=0.848 ps=4.26 w=1.6 l=0.94
X72 LELO_GR02_0.BANDGAP_0.x2.LELOATR_PCH_12C5F0_7.G LELO_GR02_0.BANDGAP_0.x2.LELOATR_PCH_12C5F0_7.G LELO_GR02_0.BANDGAP_0.x2.x2.P VDPWR sky130_fd_pr__pfet_01v8 ad=1.3728 pd=4.82 as=2.2048 ps=9.38 w=4.16 l=0.94
X73 a_17350_4886# a_17566_2966# VGND sky130_fd_pr__res_high_po w=0.36 l=7.36
X74 LELO_GR02_0.OSCILLATOR_0.x6.D LELO_GR02_0.OSCILLATOR_0.x6.XA7.CN LELO_GR02_0.OSCILLATOR_0.x6.XA7.MP2.S VDPWR sky130_fd_pr__pfet_01v8 ad=0.468 pd=2.84 as=0.288 ps=1.54 w=0.9 l=0.16
X75 VGND VGND LELO_GR02_0.BANDGAP_0.x8.DN sky130_fd_pr__pnp_05v5_W3p40L3p40
**devattr s=462400,2720
X76 LELO_GR02_0.BANDGAP_0.x8.DN a_11246_9428# VGND sky130_fd_pr__res_high_po w=0.36 l=7.36
X77 LELO_GR02_0.OSCILLATOR_0.x6.XA7.MP2.S uo_out<0> LELO_GR02_0.OSCILLATOR_0.x6.XA7.MN2.D VGND sky130_fd_pr__nfet_01v8 ad=0.288 pd=1.54 as=0.288 ps=1.54 w=0.9 l=0.16
R5 uio_oe<0> JNWTR_TIEL_CV_0.Y sky130_fd_pr__res_generic_m4 w=0.3 l=0.3
X78 LELO_GR02_0.BANDGAP_0.x5.A LELO_GR02_0.BANDGAP_0.x5.B LELO_GR02_0.OSCILLATOR_0.V_CTAT VDPWR sky130_fd_pr__pfet_01v8 ad=0.4704 pd=2.9 as=0.2784 ps=1.54 w=0.96 l=0.22
X79 LELO_GR02_0.OSCILLATOR_0.x6.XA6.MN1.S LELO_GR02_0.OSCILLATOR_0.x6.XA6.A VGND VGND sky130_fd_pr__nfet_01v8 ad=0.288 pd=1.54 as=0.468 ps=2.84 w=0.9 l=0.16
X80 VGND LELO_GR02_0.OSCILLATOR_0.PWRUP_N_1V8 LELO_GR02_0.BANDGAP_0.x2.x6.D VGND sky130_fd_pr__nfet_01v8 ad=1.4112 pd=6.74 as=0.8352 ps=3.46 w=2.88 l=0.22
X81 LELO_GR02_0.BANDGAP_0.x5.B LELO_GR02_0.BANDGAP_0.x2.x2<1>.A sky130_fd_pr__cap_mim_m3_1 l=5 w=5
X82 LELO_GR02_0.OSCILLATOR_0.x5.x9<4>.S LELO_GR02_0.OSCILLATOR_0.I_PTAT LELO_GR02_0.OSCILLATOR_0.x5.x9<4>.D VGND sky130_fd_pr__nfet_01v8 ad=0.848 pd=4.26 as=0.528 ps=2.26 w=1.6 l=0.94
X83 LELO_GR02_0.OSCILLATOR_0.x6.D LELO_GR02_0.OSCILLATOR_0.x6.XA7.C LELO_GR02_0.OSCILLATOR_0.x6.XA6.MP1.S VDPWR sky130_fd_pr__pfet_01v8 ad=0.468 pd=2.84 as=0.288 ps=1.54 w=0.9 l=0.16
X84 LELO_GR02_0.OSCILLATOR_0.PWRUP_B_1V8 LELO_GR02_0.OSCILLATOR_0.PWRUP_N_1V8 VDPWR VDPWR sky130_fd_pr__pfet_01v8 ad=0.468 pd=2.84 as=0.468 ps=2.84 w=0.9 l=0.16
X85 uo_out<0> LELO_GR02_0.OSCILLATOR_0.x6.D VGND VGND sky130_fd_pr__nfet_01v8 ad=0.468 pd=2.84 as=0.468 ps=2.84 w=0.9 l=0.16
X86 VGND VGND LELO_GR02_0.BANDGAP_0.x8.DN sky130_fd_pr__pnp_05v5_W3p40L3p40
**devattr s=462400,2720
X87 VGND ui_in<0> sky130_fd_pr__diode_pw2nd_05v5 perim=1.8e+06 area=2.025e+11
X88 LELO_GR02_0.BANDGAP_0.x5.A LELO_GR02_0.OSCILLATOR_0.PWRUP_N_1V8 VDPWR VDPWR sky130_fd_pr__pfet_01v8 ad=0.8352 pd=3.46 as=1.4112 ps=6.74 w=2.88 l=0.22
X89 LELO_GR02_0.OSCILLATOR_0.x5.x9<4>.D LELO_GR02_0.OSCILLATOR_0.I_PTAT LELO_GR02_0.OSCILLATOR_0.x5.x9<4>.S VGND sky130_fd_pr__nfet_01v8 ad=0.528 pd=2.26 as=0.848 ps=4.26 w=1.6 l=0.94
X90 LELO_GR02_0.OSCILLATOR_0.x13<2>.B LELO_GR02_0.OSCILLATOR_0.I_PTAT sky130_fd_pr__cap_mim_m3_1 l=5 w=5
X91 VGND LELO_GR02_0.BANDGAP_0.x2.x6.D LELO_GR02_0.BANDGAP_0.x2.LELOATR_NCH_4C5F0_5.D VGND sky130_fd_pr__nfet_01v8 ad=0.848 pd=4.26 as=0.528 ps=2.26 w=1.6 l=0.94
X92 LELO_GR02_0.BANDGAP_0.x2.x2.P LELO_GR02_0.BANDGAP_0.x2.LELOATR_PCH_12C5F0_7.G LELO_GR02_0.BANDGAP_0.x2.x2<1>.A VDPWR sky130_fd_pr__pfet_01v8 ad=2.2048 pd=9.38 as=1.3728 ps=4.82 w=4.16 l=0.94
X93 LELO_GR02_0.OSCILLATOR_0.x6.XA5.A LELO_GR02_0.OSCILLATOR_0.x6.XA7.CN LELO_GR02_0.OSCILLATOR_0.x6.XA4.MN1.S VGND sky130_fd_pr__nfet_01v8 ad=0.468 pd=2.84 as=0.288 ps=1.54 w=0.9 l=0.16
X94 LELO_GR02_0.BANDGAP_0.x5.B LELO_GR02_0.BANDGAP_0.x2.x2<1>.A sky130_fd_pr__cap_mim_m3_1 l=5 w=5
X95 LELO_GR02_0.OSCILLATOR_0.x5.x11.G LELO_GR02_0.OSCILLATOR_0.V_CTAT LELO_GR02_0.OSCILLATOR_0.x5.x9<4>.S VGND sky130_fd_pr__nfet_01v8 ad=0.528 pd=2.26 as=0.848 ps=4.26 w=1.6 l=0.94
X96 LELO_GR02_0.BANDGAP_0.x2.x2.P LELO_GR02_0.BANDGAP_0.x2.LELOATR_PCH_12C5F0_7.G LELO_GR02_0.BANDGAP_0.x2.LELOATR_PCH_12C5F0_7.G VDPWR sky130_fd_pr__pfet_01v8 ad=2.2048 pd=9.38 as=1.3728 ps=4.82 w=4.16 l=0.94
X97 LELO_GR02_0.OSCILLATOR_0.I_PTAT LELO_GR02_0.OSCILLATOR_0.x6.CK LELO_GR02_0.OSCILLATOR_0.x13<2>.B VGND sky130_fd_pr__nfet_01v8 ad=0.5088 pd=2.98 as=0.3168 ps=1.62 w=0.96 l=0.94
X98 a_19078_4886# a_19294_2966# VGND sky130_fd_pr__res_high_po w=0.36 l=7.36
X99 LELO_GR02_0.OSCILLATOR_0.x6.XA7.MN2.D LELO_GR02_0.OSCILLATOR_0.PWRUP_B_1V8 VGND VGND sky130_fd_pr__nfet_01v8 ad=0.288 pd=1.54 as=0.468 ps=2.84 w=0.9 l=0.16
X100 VGND LELO_GR02_0.BANDGAP_0.x2.x6.D LELO_GR02_0.BANDGAP_0.x2.LELOATR_NCH_4C5F0_5.D VGND sky130_fd_pr__nfet_01v8 ad=0.848 pd=4.26 as=0.528 ps=2.26 w=1.6 l=0.94
X101 LELO_GR02_0.BANDGAP_0.x5.B LELO_GR02_0.BANDGAP_0.x2.x2<1>.A LELO_GR02_0.BANDGAP_0.x2.x2.P VDPWR sky130_fd_pr__pfet_01v8 ad=1.3728 pd=4.82 as=2.2048 ps=9.38 w=4.16 l=0.94
X102 VDPWR VDPWR VDPWR VDPWR sky130_fd_pr__pfet_01v8 ad=0.468 pd=2.84 as=16.0632 ps=86.12 w=0.9 l=0.16
X103 LELO_GR02_0.OSCILLATOR_0.V_CTAT LELO_GR02_0.BANDGAP_0.x5.B LELO_GR02_0.BANDGAP_0.x5.A VDPWR sky130_fd_pr__pfet_01v8 ad=0.2784 pd=1.54 as=0.4704 ps=2.9 w=0.96 l=0.22
X104 LELO_GR02_0.BANDGAP_0.x5.A LELO_GR02_0.BANDGAP_0.x5.B LELO_GR02_0.BANDGAP_0.x4.D VDPWR sky130_fd_pr__pfet_01v8 ad=0.4704 pd=2.9 as=0.2784 ps=1.54 w=0.96 l=0.22
X105 LELO_GR02_0.OSCILLATOR_0.x13<2>.B LELO_GR02_0.OSCILLATOR_0.I_PTAT sky130_fd_pr__cap_mim_m3_1 l=5 w=5
X106 LELO_GR02_0.OSCILLATOR_0.x6.CK LELO_GR02_0.OSCILLATOR_0.x5.x7.G VGND VGND sky130_fd_pr__nfet_01v8 ad=0.528 pd=2.26 as=0.848 ps=4.26 w=1.6 l=0.94
X107 JNWTR_TIEL_CV_0.Y JNWTR_TIEL_CV_0.MP0.G VGND VGND sky130_fd_pr__nfet_01v8 ad=0.468 pd=2.84 as=0.468 ps=2.84 w=0.9 l=0.16
X108 LELO_GR02_0.OSCILLATOR_0.x5.x9<4>.D LELO_GR02_0.OSCILLATOR_0.x5.x11.G LELO_GR02_0.OSCILLATOR_0.x5.x11.S VDPWR sky130_fd_pr__pfet_01v8 ad=0.528 pd=2.26 as=0.848 ps=4.26 w=1.6 l=0.94
X109 a_18646_4886# a_18862_2966# VGND sky130_fd_pr__res_high_po w=0.36 l=7.36
X110 LELO_GR02_0.OSCILLATOR_0.x5.x9<4>.S LELO_GR02_0.OSCILLATOR_0.V_CTAT LELO_GR02_0.OSCILLATOR_0.x5.x11.G VGND sky130_fd_pr__nfet_01v8 ad=0.848 pd=4.26 as=0.528 ps=2.26 w=1.6 l=0.94
X111 LELO_GR02_0.BANDGAP_0.x2.x2.P LELO_GR02_0.BANDGAP_0.x2.x2<1>.A LELO_GR02_0.BANDGAP_0.x5.B VDPWR sky130_fd_pr__pfet_01v8 ad=2.2048 pd=9.38 as=1.3728 ps=4.82 w=4.16 l=0.94
X112 a_12326_11348# a_12542_9428# VGND sky130_fd_pr__res_high_po w=0.36 l=7.36
X113 LELO_GR02_0.BANDGAP_0.x5.B LELO_GR02_0.BANDGAP_0.x2.x2<1>.A sky130_fd_pr__cap_mim_m3_1 l=5 w=5
X114 a_19078_4886# a_18862_2966# VGND sky130_fd_pr__res_high_po w=0.36 l=7.36
X115 LELO_GR02_0.OSCILLATOR_0.x5.x11.S LELO_GR02_0.OSCILLATOR_0.x5.x11.G LELO_GR02_0.OSCILLATOR_0.x5.x11.G VDPWR sky130_fd_pr__pfet_01v8 ad=0.848 pd=4.26 as=0.528 ps=2.26 w=1.6 l=0.94
R6 uio_oe<5> JNWTR_TIEL_CV_0.Y sky130_fd_pr__res_generic_m4 w=0.3 l=0.3
X116 LELO_GR02_0.BANDGAP_0.x5.B LELO_GR02_0.BANDGAP_0.x2.x6.D VGND VGND sky130_fd_pr__nfet_01v8 ad=0.528 pd=2.26 as=0.848 ps=4.26 w=1.6 l=0.94
X117 LELO_GR02_0.BANDGAP_0.x2.x2<1>.A LELO_GR02_0.BANDGAP_0.x2.LELOATR_PCH_12C5F0_7.G LELO_GR02_0.BANDGAP_0.x2.x2.P VDPWR sky130_fd_pr__pfet_01v8 ad=1.3728 pd=4.82 as=2.2048 ps=9.38 w=4.16 l=0.94
X118 VGND LELO_GR02_0.OSCILLATOR_0.PWRUP_N_1V8 LELO_GR02_0.OSCILLATOR_0.x6.CK VGND sky130_fd_pr__nfet_01v8 ad=1.4112 pd=6.74 as=0.8352 ps=3.46 w=2.88 l=0.22
X119 VDPWR VDPWR VDPWR VDPWR sky130_fd_pr__pfet_01v8 ad=0.468 pd=2.84 as=0 ps=0 w=0.9 l=0.16
X120 LELO_GR02_0.OSCILLATOR_0.x5.x11.G LELO_GR02_0.OSCILLATOR_0.V_CTAT LELO_GR02_0.OSCILLATOR_0.x5.x9<4>.S VGND sky130_fd_pr__nfet_01v8 ad=0.528 pd=2.26 as=0.848 ps=4.26 w=1.6 l=0.94
X121 a_18646_4886# a_18430_2966# VGND sky130_fd_pr__res_high_po w=0.36 l=7.36
X122 LELO_GR02_0.BANDGAP_0.x2.x2.P LELO_GR02_0.BANDGAP_0.x2.LELOATR_PCH_12C5F0_7.G LELO_GR02_0.BANDGAP_0.x2.x2<1>.A VDPWR sky130_fd_pr__pfet_01v8 ad=2.2048 pd=9.38 as=1.3728 ps=4.82 w=4.16 l=0.94
X123 VGND LELO_GR02_0.BANDGAP_0.x2.x6.D LELO_GR02_0.BANDGAP_0.x2.x6.D VGND sky130_fd_pr__nfet_01v8 ad=0.848 pd=4.26 as=0.528 ps=2.26 w=1.6 l=0.94
X124 VGND VGND LELO_GR02_0.BANDGAP_0.x8.DN sky130_fd_pr__pnp_05v5_W3p40L3p40
**devattr s=462400,2720
X125 LELO_GR02_0.OSCILLATOR_0.x5.x9<4>.D LELO_GR02_0.OSCILLATOR_0.I_PTAT LELO_GR02_0.OSCILLATOR_0.x5.x9<4>.S VGND sky130_fd_pr__nfet_01v8 ad=0.528 pd=2.26 as=0.848 ps=4.26 w=1.6 l=0.94
X126 LELO_GR02_0.BANDGAP_0.x2.x2.P LELO_GR02_0.BANDGAP_0.x2.LELOATR_PCH_12C5F0_7.G LELO_GR02_0.BANDGAP_0.x2.LELOATR_PCH_12C5F0_7.G VDPWR sky130_fd_pr__pfet_01v8 ad=2.2048 pd=9.38 as=1.3728 ps=4.82 w=4.16 l=0.94
X127 LELO_GR02_0.BANDGAP_0.x2.LELOATR_PCH_12C5F0_7.G LELO_GR02_0.BANDGAP_0.x2.LELOATR_PCH_12C5F0_7.G LELO_GR02_0.BANDGAP_0.x2.x2.P VDPWR sky130_fd_pr__pfet_01v8 ad=1.3728 pd=4.82 as=2.2048 ps=9.38 w=4.16 l=0.94
X128 a_12326_11348# a_12110_9428# VGND sky130_fd_pr__res_high_po w=0.36 l=7.36
X129 LELO_GR02_0.BANDGAP_0.x5.B LELO_GR02_0.BANDGAP_0.x2.x6.D VGND VGND sky130_fd_pr__nfet_01v8 ad=0.528 pd=2.26 as=0.848 ps=4.26 w=1.6 l=0.94
X130 LELO_GR02_0.OSCILLATOR_0.x6.XA3.MP1.S LELO_GR02_0.OSCILLATOR_0.x6.D VDPWR VDPWR sky130_fd_pr__pfet_01v8 ad=0.288 pd=1.54 as=0.468 ps=2.84 w=0.9 l=0.16
X131 LELO_GR02_0.OSCILLATOR_0.x13<2>.B LELO_GR02_0.OSCILLATOR_0.I_PTAT sky130_fd_pr__cap_mim_m3_1 l=5 w=5
X132 LELO_GR02_0.OSCILLATOR_0.x5.x7.G a_20158_2966# VGND sky130_fd_pr__res_high_po w=0.36 l=7.36
X133 a_17350_4886# a_17134_2966# VGND sky130_fd_pr__res_high_po w=0.36 l=7.36
X134 LELO_GR02_0.OSCILLATOR_0.x6.CK LELO_GR02_0.OSCILLATOR_0.PWRUP_N_1V8 VGND VGND sky130_fd_pr__nfet_01v8 ad=0.8352 pd=3.46 as=1.4112 ps=6.74 w=2.88 l=0.22
X135 LELO_GR02_0.OSCILLATOR_0.x6.XA1.MN1.S LELO_GR02_0.OSCILLATOR_0.x6.CK VGND VGND sky130_fd_pr__nfet_01v8 ad=0.288 pd=1.54 as=0.468 ps=2.84 w=0.9 l=0.16
X136 LELO_GR02_0.OSCILLATOR_0.PWRUP_N_1V8 ui_in<0> VGND VGND sky130_fd_pr__nfet_01v8 ad=0.468 pd=2.84 as=0.468 ps=2.84 w=0.9 l=0.16
X137 LELO_GR02_0.BANDGAP_0.x5.B LELO_GR02_0.BANDGAP_0.x2.x2<1>.A LELO_GR02_0.BANDGAP_0.x2.x2.P VDPWR sky130_fd_pr__pfet_01v8 ad=1.3728 pd=4.82 as=2.2048 ps=9.38 w=4.16 l=0.94
X138 LELO_GR02_0.BANDGAP_0.x2.LELOATR_NCH_4C5F0_5.D LELO_GR02_0.BANDGAP_0.x4.D LELO_GR02_0.BANDGAP_0.x2.x2<1>.A VGND sky130_fd_pr__nfet_01v8 ad=0.848 pd=4.26 as=0.528 ps=2.26 w=1.6 l=0.94
X139 VDPWR LELO_GR02_0.OSCILLATOR_0.PWRUP_B_1V8 LELO_GR02_0.OSCILLATOR_0.x6.XA7.C VDPWR sky130_fd_pr__pfet_01v8 ad=0.468 pd=2.84 as=0.288 ps=1.54 w=0.9 l=0.16
X140 VGND LELO_GR02_0.BANDGAP_0.x2.x6.D LELO_GR02_0.BANDGAP_0.x2.x6.D VGND sky130_fd_pr__nfet_01v8 ad=0.848 pd=4.26 as=0.528 ps=2.26 w=1.6 l=0.94
X141 LELO_GR02_0.OSCILLATOR_0.x5.x9<4>.S LELO_GR02_0.OSCILLATOR_0.I_PTAT LELO_GR02_0.OSCILLATOR_0.x5.x9<4>.D VGND sky130_fd_pr__nfet_01v8 ad=0.848 pd=4.26 as=0.528 ps=2.26 w=1.6 l=0.94
X142 LELO_GR02_0.OSCILLATOR_0.x13<2>.B LELO_GR02_0.OSCILLATOR_0.I_PTAT sky130_fd_pr__cap_mim_m3_1 l=5 w=5
X143 VGND VGND LELO_GR02_0.BANDGAP_0.x8.DN sky130_fd_pr__pnp_05v5_W3p40L3p40
**devattr s=462400,2720
X144 LELO_GR02_0.OSCILLATOR_0.x5.x7.G LELO_GR02_0.OSCILLATOR_0.PWRUP_N_1V8 VGND VGND sky130_fd_pr__nfet_01v8 ad=0.8352 pd=3.46 as=1.4112 ps=6.74 w=2.88 l=0.22
X145 LELO_GR02_0.OSCILLATOR_0.x5.x9<4>.S LELO_GR02_0.OSCILLATOR_0.V_CTAT LELO_GR02_0.OSCILLATOR_0.x5.x11.G VGND sky130_fd_pr__nfet_01v8 ad=0.848 pd=4.26 as=0.528 ps=2.26 w=1.6 l=0.94
X146 a_19942_4886# a_20158_2966# VGND sky130_fd_pr__res_high_po w=0.36 l=7.36
X147 VGND VGND LELO_GR02_0.BANDGAP_0.x8.DN sky130_fd_pr__pnp_05v5_W3p40L3p40
**devattr s=462400,2720
X148 LELO_GR02_0.OSCILLATOR_0.x5.x11.S a_17134_2966# VGND sky130_fd_pr__res_high_po w=0.36 l=7.36
X149 VGND LELO_GR02_0.OSCILLATOR_0.x5.x7.G LELO_GR02_0.OSCILLATOR_0.x5.x7.G VGND sky130_fd_pr__nfet_01v8 ad=0.848 pd=4.26 as=0.528 ps=2.26 w=1.6 l=0.94
X150 LELO_GR02_0.OSCILLATOR_0.x5.x9<4>.D LELO_GR02_0.OSCILLATOR_0.I_PTAT LELO_GR02_0.OSCILLATOR_0.x5.x9<4>.S VGND sky130_fd_pr__nfet_01v8 ad=0.528 pd=2.26 as=0.848 ps=4.26 w=1.6 l=0.94
X151 LELO_GR02_0.OSCILLATOR_0.x6.XA7.MP2.S uo_out<0> VDPWR VDPWR sky130_fd_pr__pfet_01v8 ad=0.288 pd=1.54 as=0.288 ps=1.54 w=0.9 l=0.16
X152 LELO_GR02_0.BANDGAP_0.x2.x2.P LELO_GR02_0.BANDGAP_0.x2.LELOATR_PCH_12C5F0_7.G LELO_GR02_0.BANDGAP_0.x2.x2<1>.A VDPWR sky130_fd_pr__pfet_01v8 ad=2.2048 pd=9.38 as=1.3728 ps=4.82 w=4.16 l=0.94
X153 LELO_GR02_0.OSCILLATOR_0.x13<2>.B LELO_GR02_0.OSCILLATOR_0.I_PTAT sky130_fd_pr__cap_mim_m3_1 l=5 w=5
X154 LELO_GR02_0.OSCILLATOR_0.x6.XA6.MP1.S LELO_GR02_0.OSCILLATOR_0.x6.XA6.A VDPWR VDPWR sky130_fd_pr__pfet_01v8 ad=0.288 pd=1.54 as=0.468 ps=2.84 w=0.9 l=0.16
X155 VGND LELO_GR02_0.OSCILLATOR_0.PWRUP_N_1V8 LELO_GR02_0.OSCILLATOR_0.x5.x7.G VGND sky130_fd_pr__nfet_01v8 ad=1.4112 pd=6.74 as=0.8352 ps=3.46 w=2.88 l=0.22
X156 a_6491_5710# a_6275_3790# VGND sky130_fd_pr__res_high_po w=0.36 l=7.36
X157 VGND LELO_GR02_0.OSCILLATOR_0.x5.x7.G LELO_GR02_0.OSCILLATOR_0.x5.x9<4>.S VGND sky130_fd_pr__nfet_01v8 ad=0.848 pd=4.26 as=0.528 ps=2.26 w=1.6 l=0.94
X158 LELO_GR02_0.BANDGAP_0.x2.x6.D LELO_GR02_0.OSCILLATOR_0.PWRUP_N_1V8 VGND VGND sky130_fd_pr__nfet_01v8 ad=0.8352 pd=3.46 as=1.4112 ps=6.74 w=2.88 l=0.22
R7 uio_oe<4> JNWTR_TIEL_CV_0.Y sky130_fd_pr__res_generic_m4 w=0.3 l=0.3
X159 LELO_GR02_0.OSCILLATOR_0.x6.XA7.CN LELO_GR02_0.OSCILLATOR_0.x6.XA7.C VGND VGND sky130_fd_pr__nfet_01v8 ad=0.468 pd=2.84 as=0.468 ps=2.84 w=0.9 l=0.16
X160 LELO_GR02_0.BANDGAP_0.x2.x2.P LELO_GR02_0.BANDGAP_0.x2.LELOATR_PCH_12C5F0_7.G LELO_GR02_0.BANDGAP_0.x2.LELOATR_PCH_12C5F0_7.G VDPWR sky130_fd_pr__pfet_01v8 ad=2.2048 pd=9.38 as=1.3728 ps=4.82 w=4.16 l=0.94
X161 LELO_GR02_0.BANDGAP_0.x2.LELOATR_PCH_12C5F0_7.G LELO_GR02_0.OSCILLATOR_0.V_CTAT LELO_GR02_0.BANDGAP_0.x2.LELOATR_NCH_4C5F0_5.D VGND sky130_fd_pr__nfet_01v8 ad=0.528 pd=2.26 as=0.848 ps=4.26 w=1.6 l=0.94
X162 LELO_GR02_0.OSCILLATOR_0.x5.x11.S LELO_GR02_0.OSCILLATOR_0.x5.x9<4>.D LELO_GR02_0.OSCILLATOR_0.x6.CK VDPWR sky130_fd_pr__pfet_01v8_lvt ad=0.848 pd=4.26 as=0.528 ps=2.26 w=1.6 l=0.94
X163 JNWTR_TIEL_CV_0.MP0.G JNWTR_TIEL_CV_0.MP0.G VDPWR VDPWR sky130_fd_pr__pfet_01v8 ad=0.468 pd=2.84 as=0.468 ps=2.84 w=0.9 l=0.16
X164 LELO_GR02_0.BANDGAP_0.x5.B LELO_GR02_0.BANDGAP_0.x2.x2<1>.A LELO_GR02_0.BANDGAP_0.x2.x2.P VDPWR sky130_fd_pr__pfet_01v8 ad=1.3728 pd=4.82 as=2.2048 ps=9.38 w=4.16 l=0.94
X165 uo_out<0> LELO_GR02_0.OSCILLATOR_0.x6.D VDPWR VDPWR sky130_fd_pr__pfet_01v8 ad=0.468 pd=2.84 as=0.468 ps=2.84 w=0.9 l=0.16
X166 a_19942_4886# a_19726_2966# VGND sky130_fd_pr__res_high_po w=0.36 l=7.36
X167 VGND LELO_GR02_0.OSCILLATOR_0.PWRUP_N_1V8 LELO_GR02_0.OSCILLATOR_0.x6.CK VGND sky130_fd_pr__nfet_01v8 ad=1.4112 pd=6.74 as=0.8352 ps=3.46 w=2.88 l=0.22
X168 VGND VGND LELO_GR02_0.BANDGAP_0.x8.DN sky130_fd_pr__pnp_05v5_W3p40L3p40
**devattr s=462400,2720
X169 LELO_GR02_0.OSCILLATOR_0.x5.x9<4>.S LELO_GR02_0.OSCILLATOR_0.I_PTAT LELO_GR02_0.OSCILLATOR_0.x5.x9<4>.D VGND sky130_fd_pr__nfet_01v8 ad=0.848 pd=4.26 as=0.528 ps=2.26 w=1.6 l=0.94
X170 LELO_GR02_0.BANDGAP_0.x5.B LELO_GR02_0.BANDGAP_0.x2.x2<1>.A sky130_fd_pr__cap_mim_m3_1 l=5 w=5
X171 a_6059_5710# a_6275_3790# VGND sky130_fd_pr__res_high_po w=0.36 l=7.36
X172 LELO_GR02_0.OSCILLATOR_0.x6.XA5.A LELO_GR02_0.OSCILLATOR_0.x6.XA7.C LELO_GR02_0.OSCILLATOR_0.x6.XA4.MP1.S VDPWR sky130_fd_pr__pfet_01v8 ad=0.468 pd=2.84 as=0.288 ps=1.54 w=0.9 l=0.16
X173 LELO_GR02_0.OSCILLATOR_0.x6.XA5.A LELO_GR02_0.OSCILLATOR_0.x6.XA7.C LELO_GR02_0.OSCILLATOR_0.x6.XA3.MN1.S VGND sky130_fd_pr__nfet_01v8 ad=0.468 pd=2.84 as=0.288 ps=1.54 w=0.9 l=0.16
X174 LELO_GR02_0.OSCILLATOR_0.x6.XA4.MN1.S LELO_GR02_0.OSCILLATOR_0.x6.XA6.A VGND VGND sky130_fd_pr__nfet_01v8 ad=0.288 pd=1.54 as=0.468 ps=2.84 w=0.9 l=0.16
X175 a_19510_4886# a_19726_2966# VGND sky130_fd_pr__res_high_po w=0.36 l=7.36
X176 LELO_GR02_0.BANDGAP_0.x4.D LELO_GR02_0.BANDGAP_0.x5.B LELO_GR02_0.BANDGAP_0.x5.A VDPWR sky130_fd_pr__pfet_01v8 ad=0.2784 pd=1.54 as=0.4704 ps=2.9 w=0.96 l=0.22
X177 LELO_GR02_0.OSCILLATOR_0.x5.x9<4>.S LELO_GR02_0.OSCILLATOR_0.V_CTAT LELO_GR02_0.OSCILLATOR_0.x5.x11.G VGND sky130_fd_pr__nfet_01v8 ad=0.848 pd=4.26 as=0.528 ps=2.26 w=1.6 l=0.94
X178 a_5627_5710# a_5843_3790# VGND sky130_fd_pr__res_high_po w=0.36 l=7.36
X179 VDPWR LELO_GR02_0.OSCILLATOR_0.PWRUP_B_1V8 LELO_GR02_0.OSCILLATOR_0.x6.XA7.MP2.S VDPWR sky130_fd_pr__pfet_01v8 ad=0.288 pd=1.54 as=0.468 ps=2.84 w=0.9 l=0.16
X180 LELO_GR02_0.BANDGAP_0.x5.B LELO_GR02_0.BANDGAP_0.x2.x2<1>.A sky130_fd_pr__cap_mim_m3_1 l=5 w=5
X181 VGND VGND LELO_GR02_0.BANDGAP_0.x8.DN sky130_fd_pr__pnp_05v5_W3p40L3p40
**devattr s=462400,2720
X182 VGND LELO_GR02_0.OSCILLATOR_0.PWRUP_N_1V8 LELO_GR02_0.BANDGAP_0.x5.B VGND sky130_fd_pr__nfet_01v8 ad=1.4112 pd=6.74 as=0.8352 ps=3.46 w=2.88 l=0.22
X183 a_6059_5710# a_5843_3790# VGND sky130_fd_pr__res_high_po w=0.36 l=7.36
X184 VDPWR LELO_GR02_0.OSCILLATOR_0.PWRUP_N_1V8 LELO_GR02_0.OSCILLATOR_0.x5.x11.S VDPWR sky130_fd_pr__pfet_01v8 ad=1.4112 pd=6.74 as=0.8352 ps=3.46 w=2.88 l=0.22
X185 LELO_GR02_0.OSCILLATOR_0.x5.x11.G LELO_GR02_0.OSCILLATOR_0.V_CTAT LELO_GR02_0.OSCILLATOR_0.x5.x9<4>.S VGND sky130_fd_pr__nfet_01v8 ad=0.528 pd=2.26 as=0.848 ps=4.26 w=1.6 l=0.94
X186 LELO_GR02_0.OSCILLATOR_0.x13<2>.B LELO_GR02_0.OSCILLATOR_0.I_PTAT sky130_fd_pr__cap_mim_m3_1 l=5 w=5
X187 a_11894_11348# a_11678_9428# VGND sky130_fd_pr__res_high_po w=0.36 l=7.36
X188 LELO_GR02_0.OSCILLATOR_0.x6.XA6.A LELO_GR02_0.OSCILLATOR_0.x6.XA5.A VGND VGND sky130_fd_pr__nfet_01v8 ad=0.468 pd=2.84 as=0.468 ps=2.84 w=0.9 l=0.16
X189 a_18214_4886# a_18430_2966# VGND sky130_fd_pr__res_high_po w=0.36 l=7.36
X190 LELO_GR02_0.BANDGAP_0.x5.A LELO_GR02_0.BANDGAP_0.x5.B LELO_GR02_0.OSCILLATOR_0.I_PTAT VDPWR sky130_fd_pr__pfet_01v8 ad=0.4704 pd=2.9 as=0.2784 ps=1.54 w=0.96 l=0.22
X191 a_5627_5710# a_5411_3790# VGND sky130_fd_pr__res_high_po w=0.36 l=7.36
X192 a_11894_11348# a_12110_9428# VGND sky130_fd_pr__res_high_po w=0.36 l=7.36
X193 VDPWR LELO_GR02_0.OSCILLATOR_0.PWRUP_N_1V8 LELO_GR02_0.BANDGAP_0.x2.x2.P VDPWR sky130_fd_pr__pfet_01v8 ad=1.4112 pd=6.74 as=0.8352 ps=3.46 w=2.88 l=0.22
X194 a_17782_4886# a_17998_2966# VGND sky130_fd_pr__res_high_po w=0.36 l=7.36
X195 LELO_GR02_0.OSCILLATOR_0.x6.D LELO_GR02_0.OSCILLATOR_0.x6.XA7.C LELO_GR02_0.OSCILLATOR_0.x6.XA7.MP2.S VGND sky130_fd_pr__nfet_01v8 ad=0.468 pd=2.84 as=0.288 ps=1.54 w=0.9 l=0.16
X196 LELO_GR02_0.BANDGAP_0.x2.x2.P LELO_GR02_0.BANDGAP_0.x2.x2<1>.A LELO_GR02_0.BANDGAP_0.x5.B VDPWR sky130_fd_pr__pfet_01v8 ad=2.2048 pd=9.38 as=1.3728 ps=4.82 w=4.16 l=0.94
X197 a_11462_11348# a_11678_9428# VGND sky130_fd_pr__res_high_po w=0.36 l=7.36
X198 VGND VGND LELO_GR02_0.OSCILLATOR_0.V_CTAT sky130_fd_pr__pnp_05v5_W3p40L3p40
**devattr s=462400,2720
X199 a_18214_4886# a_17998_2966# VGND sky130_fd_pr__res_high_po w=0.36 l=7.36
X200 LELO_GR02_0.OSCILLATOR_0.x6.CK LELO_GR02_0.OSCILLATOR_0.PWRUP_N_1V8 VGND VGND sky130_fd_pr__nfet_01v8 ad=0.8352 pd=3.46 as=1.4112 ps=6.74 w=2.88 l=0.22
X201 LELO_GR02_0.BANDGAP_0.x2.LELOATR_NCH_4C5F0_5.D LELO_GR02_0.BANDGAP_0.x2.x6.D VGND VGND sky130_fd_pr__nfet_01v8 ad=0.528 pd=2.26 as=0.848 ps=4.26 w=1.6 l=0.94
X202 VGND LELO_GR02_0.OSCILLATOR_0.x5.x7.G LELO_GR02_0.OSCILLATOR_0.x6.CK VGND sky130_fd_pr__nfet_01v8 ad=0.848 pd=4.26 as=0.528 ps=2.26 w=1.6 l=0.94
X203 LELO_GR02_0.BANDGAP_0.x2.x2<1>.A LELO_GR02_0.BANDGAP_0.x2.LELOATR_PCH_12C5F0_7.G LELO_GR02_0.BANDGAP_0.x2.x2.P VDPWR sky130_fd_pr__pfet_01v8 ad=1.3728 pd=4.82 as=2.2048 ps=9.38 w=4.16 l=0.94
X204 LELO_GR02_0.OSCILLATOR_0.x5.x9<4>.S LELO_GR02_0.OSCILLATOR_0.I_PTAT LELO_GR02_0.OSCILLATOR_0.x5.x9<4>.D VGND sky130_fd_pr__nfet_01v8 ad=0.848 pd=4.26 as=0.528 ps=2.26 w=1.6 l=0.94
C0 a_9590_13714# a_9590_13461# 0.05389f
C1 LELO_GR02_0.BANDGAP_0.x2.x2<1>.A a_5506_12200# 0.02981f
C2 LELO_GR02_0.BANDGAP_0.x2.x2.P a_3743_10332# 0.11167f
C3 LELO_GR02_0.OSCILLATOR_0.PWRUP_N_1V8 a_7642_9858# 0.02404f
C4 LELO_GR02_0.BANDGAP_0.x2.x2<1>.A VDPWR 8.68177f
C5 LELO_GR02_0.BANDGAP_0.x5.B a_5195_3790# 0.01622f
C6 a_21585_8295# VDPWR 0.35757f
C7 LELO_GR02_0.BANDGAP_0.x4.D a_11462_11348# 0.10805f
C8 a_3635_9859# LELO_GR02_0.BANDGAP_0.x2.x6.D 0.0106f
C9 LELO_GR02_0.OSCILLATOR_0.PWRUP_B_1V8 a_15861_9786# 0.01877f
C10 LELO_GR02_0.OSCILLATOR_0.x5.x9<4>.D a_20567_12681# 0.0713f
C11 LELO_GR02_0.OSCILLATOR_0.x5.x7.G a_17426_6366# 0.02792f
C12 a_5507_13136# a_5506_13000# 0.23356f
C13 LELO_GR02_0.BANDGAP_0.x2.x2<1>.A a_7268_13000# 0.07583f
C14 LELO_GR02_0.BANDGAP_0.x5.A a_9590_11622# 0.0498f
C15 LELO_GR02_0.BANDGAP_0.x2.x2.P a_5506_11132# 0.16162f
C16 a_3744_13136# VDPWR 0.67392f
C17 LELO_GR02_0.OSCILLATOR_0.x6.XA6.A a_21585_9895# 0.06533f
C18 LELO_GR02_0.OSCILLATOR_0.PWRUP_B_1V8 a_8598_17876# 0.03093f
C19 LELO_GR02_0.BANDGAP_0.x2.x2<1>.A a_5411_3790# 0.01221f
C20 LELO_GR02_0.BANDGAP_0.x5.B a_7023_7034# 0.01404f
C21 LELO_GR02_0.OSCILLATOR_0.V_CTAT LELO_GR02_0.OSCILLATOR_0.x5.x9<4>.S 3.34753f
C22 LELO_GR02_0.OSCILLATOR_0.PWRUP_B_1V8 a_15861_9946# 0.0956f
C23 LELO_GR02_0.OSCILLATOR_0.x5.x9<4>.D a_20567_13481# 0.07106f
C24 a_17426_7922# a_17426_7762# 0.15007f
C25 LELO_GR02_0.OSCILLATOR_0.x5.x7.G a_17426_6526# 0.03899f
C26 uio_in<6> uio_in<5> 0.03102f
C27 LELO_GR02_0.BANDGAP_0.x5.B a_9590_13301# 0.08179f
C28 LELO_GR02_0.BANDGAP_0.x5.A a_9590_11782# 0.0635f
C29 LELO_GR02_0.BANDGAP_0.x2.x2.P a_3743_11132# 0.14807f
C30 LELO_GR02_0.OSCILLATOR_0.x6.XA7.C a_21585_9095# 0.1046f
C31 a_5507_13936# VDPWR 0.87123f
C32 LELO_GR02_0.OSCILLATOR_0.x6.XA6.A a_20745_9895# 0.05912f
C33 a_8598_18196# a_8598_17876# 0.01f
C34 LELO_GR02_0.OSCILLATOR_0.PWRUP_B_1V8 a_7758_17876# 0.01054f
C35 LELO_GR02_0.OSCILLATOR_0.PWRUP_N_1V8 a_18185_16361# 0.08518f
C36 LELO_GR02_0.OSCILLATOR_0.x13<2>.B LELO_GR02_0.OSCILLATOR_0.x5.x9<4>.S 0.04789f
C37 a_15861_10586# a_15861_10426# 0.15007f
C38 a_21585_8615# VDPWR 0.40085f
C39 LELO_GR02_0.OSCILLATOR_0.V_CTAT a_17682_14315# 0.07043f
C40 LELO_GR02_0.OSCILLATOR_0.x5.x9<4>.D a_18932_10314# 0.013f
C41 LELO_GR02_0.BANDGAP_0.x5.A LELO_GR02_0.BANDGAP_0.x4.D 1.82416f
C42 a_9590_13874# a_9590_13714# 0.0971f
C43 LELO_GR02_0.BANDGAP_0.x5.B a_9590_13461# 0.01182f
C44 LELO_GR02_0.BANDGAP_0.x2.x2<1>.A a_5506_13000# 0.03708f
C45 LELO_GR02_0.BANDGAP_0.x2.LELOATR_PCH_12C5F0_7.G a_5506_12200# 0.07582f
C46 LELO_GR02_0.OSCILLATOR_0.x6.XA7.C a_20745_9095# 0.09819f
C47 LELO_GR02_0.OSCILLATOR_0.x6.XA7.CN a_21585_9415# 0.04767f
C48 LELO_GR02_0.BANDGAP_0.x2.LELOATR_PCH_12C5F0_7.G VDPWR 15.2981f
C49 LELO_GR02_0.OSCILLATOR_0.x6.XA6.A LELO_GR02_0.OSCILLATOR_0.x6.XA4.MP1.S 0.01889f
C50 LELO_GR02_0.OSCILLATOR_0.x6.CK a_18932_7762# 0.04513f
C51 LELO_GR02_0.OSCILLATOR_0.PWRUP_N_1V8 LELO_GR02_0.OSCILLATOR_0.x5.x11.S 3.05875f
C52 LELO_GR02_0.BANDGAP_0.x2.x2<1>.A a_5195_3790# 0.04575f
C53 LELO_GR02_0.OSCILLATOR_0.x6.CK LELO_GR02_0.OSCILLATOR_0.x5.x9<4>.S 0.54121f
C54 LELO_GR02_0.BANDGAP_0.x4.D LELO_GR02_0.BANDGAP_0.x8.DN 0.45024f
C55 LELO_GR02_0.OSCILLATOR_0.V_CTAT a_15861_10426# 0.02466f
C56 a_3635_9859# a_3635_9699# 0.15007f
C57 LELO_GR02_0.OSCILLATOR_0.PWRUP_N_1V8 LELO_GR02_0.OSCILLATOR_0.x5.x7.G 1.28857f
C58 uio_in<7> uio_in<6> 0.03102f
C59 LELO_GR02_0.OSCILLATOR_0.V_CTAT a_9590_13714# 0.01608f
C60 LELO_GR02_0.BANDGAP_0.x5.B a_7269_13136# 0.03669f
C61 LELO_GR02_0.OSCILLATOR_0.PWRUP_N_1V8 a_3635_9219# 0.08291f
C62 LELO_GR02_0.OSCILLATOR_0.x6.XA7.C a_21585_9415# 0.06658f
C63 LELO_GR02_0.OSCILLATOR_0.x6.XA7.CN a_20745_9415# 0.04737f
C64 a_3744_13936# VDPWR 0.85892f
C65 LELO_GR02_0.OSCILLATOR_0.x6.CK a_18932_7922# 0.04696f
C66 a_7758_18196# a_7758_17876# 0.01f
C67 a_8598_18196# LELO_GR02_0.OSCILLATOR_0.PWRUP_B_1V8 0.01809f
C68 LELO_GR02_0.OSCILLATOR_0.PWRUP_N_1V8 a_18185_16841# 0.08704f
C69 a_16245_11265# a_15861_10586# 0.01774f
C70 LELO_GR02_0.OSCILLATOR_0.x13<2>.B a_15861_10426# 0.04654f
C71 a_18932_6526# a_18932_6366# 0.15007f
C72 LELO_GR02_0.OSCILLATOR_0.V_CTAT a_15861_10586# 0.01332f
C73 LELO_GR02_0.OSCILLATOR_0.x5.x9<4>.D a_18932_11114# 0.03425f
C74 a_3744_13136# a_3743_13000# 0.23356f
C75 LELO_GR02_0.OSCILLATOR_0.V_CTAT a_9590_13874# 0.0362f
C76 LELO_GR02_0.BANDGAP_0.x5.B a_9590_13714# 0.01116f
C77 LELO_GR02_0.BANDGAP_0.x2.LELOATR_PCH_12C5F0_7.G a_3743_12200# 0.11317f
C78 LELO_GR02_0.BANDGAP_0.x2.x2.P a_7268_11266# 0.14879f
C79 LELO_GR02_0.OSCILLATOR_0.PWRUP_N_1V8 LELO_GR02_0.BANDGAP_0.x2.x6.D 0.29307f
C80 LELO_GR02_0.OSCILLATOR_0.x6.XA7.CN LELO_GR02_0.OSCILLATOR_0.x6.XA3.MP1.S 0.03112f
C81 LELO_GR02_0.OSCILLATOR_0.x6.XA7.C a_20745_9415# 0.07292f
C82 a_9590_14354# VDPWR 0.36753f
C83 LELO_GR02_0.OSCILLATOR_0.x6.XA5.A LELO_GR02_0.OSCILLATOR_0.x6.XA4.MN1.S 0.07879f
C84 a_7758_18196# LELO_GR02_0.OSCILLATOR_0.PWRUP_B_1V8 0.01772f
C85 LELO_GR02_0.OSCILLATOR_0.x13<2>.B a_15861_10586# 0.10216f
C86 LELO_GR02_0.OSCILLATOR_0.PWRUP_B_1V8 LELO_GR02_0.OSCILLATOR_0.x6.XA5.A 0.07611f
C87 a_7269_13936# a_7269_13136# 0.01761f
C88 LELO_GR02_0.BANDGAP_0.x5.B a_9590_13874# 0.08121f
C89 LELO_GR02_0.BANDGAP_0.x2.LELOATR_PCH_12C5F0_7.G a_5506_13000# 0.07583f
C90 LELO_GR02_0.OSCILLATOR_0.PWRUP_N_1V8 LELO_GR02_0.BANDGAP_0.x2.LELOATR_NCH_4C5F0_5.D 0.06978f
C91 LELO_GR02_0.OSCILLATOR_0.x6.XA7.CN LELO_GR02_0.OSCILLATOR_0.x6.XA3.MN1.S 0.0238f
C92 LELO_GR02_0.OSCILLATOR_0.V_CTAT m1_5524_9447# 0.04223f
C93 a_9590_14514# VDPWR 0.52354f
C94 LELO_GR02_0.OSCILLATOR_0.x6.XA5.A a_21585_10375# 0.07964f
C95 LELO_GR02_0.OSCILLATOR_0.PWRUP_N_1V8 a_8598_17876# 0.06459f
C96 LELO_GR02_0.OSCILLATOR_0.x13<2>.B a_16245_11265# 0.07726f
C97 a_5506_10332# a_5141_9860# 0.01746f
C98 LELO_GR02_0.OSCILLATOR_0.V_CTAT LELO_GR02_0.OSCILLATOR_0.x13<2>.B 0.99148f
C99 LELO_GR02_0.OSCILLATOR_0.x5.x11.G a_17682_10315# 0.013f
C100 LELO_GR02_0.OSCILLATOR_0.x5.x9<4>.D a_18932_11914# 0.03457f
C101 LELO_GR02_0.OSCILLATOR_0.x5.x9<4>.D LELO_GR02_0.OSCILLATOR_0.I_PTAT 1.90816f
C102 LELO_GR02_0.BANDGAP_0.x2.x2<1>.A a_7269_13136# 0.07575f
C103 LELO_GR02_0.BANDGAP_0.x5.B LELO_GR02_0.OSCILLATOR_0.V_CTAT 1.20574f
C104 LELO_GR02_0.BANDGAP_0.x2.LELOATR_PCH_12C5F0_7.G a_3743_13000# 0.11473f
C105 LELO_GR02_0.OSCILLATOR_0.PWRUP_N_1V8 a_5141_9860# 0.01241f
C106 LELO_GR02_0.OSCILLATOR_0.x6.XA7.C LELO_GR02_0.OSCILLATOR_0.x6.XA3.MN1.S 0.01916f
C107 LELO_GR02_0.OSCILLATOR_0.x6.XA7.CN a_21585_9895# 0.08626f
C108 LELO_GR02_0.OSCILLATOR_0.x6.D a_21585_9415# 0.06129f
C109 a_18932_14700# VDPWR 0.47166f
C110 LELO_GR02_0.OSCILLATOR_0.x6.XA5.A a_20745_10375# 0.09561f
C111 a_21585_10695# a_21585_10375# 0.01f
C112 a_8598_18706# a_8598_18196# 0.02008f
C113 LELO_GR02_0.OSCILLATOR_0.PWRUP_N_1V8 a_7758_17876# 0.10719f
C114 LELO_GR02_0.BANDGAP_0.x2.x2.P a_7139_3790# 0.0211f
C115 LELO_GR02_0.BANDGAP_0.x5.B a_7023_7834# 0.03136f
C116 LELO_GR02_0.OSCILLATOR_0.x6.CK a_16245_11265# 0.0771f
C117 LELO_GR02_0.BANDGAP_0.x4.D a_6392_9060# 0.06905f
C118 LELO_GR02_0.OSCILLATOR_0.V_CTAT LELO_GR02_0.OSCILLATOR_0.x6.CK 0.22732f
C119 uo_out<2> uo_out<1> 0.03102f
C120 LELO_GR02_0.BANDGAP_0.x2.x2.P LELO_GR02_0.BANDGAP_0.x4.D 1.39722f
C121 LELO_GR02_0.OSCILLATOR_0.PWRUP_N_1V8 a_3635_9699# 0.08761f
C122 LELO_GR02_0.OSCILLATOR_0.x6.XA7.CN a_20745_9895# 0.02602f
C123 LELO_GR02_0.OSCILLATOR_0.x6.D a_20745_9415# 0.05912f
C124 LELO_GR02_0.OSCILLATOR_0.x5.x9<4>.D VDPWR 2.14048f
C125 LELO_GR02_0.OSCILLATOR_0.PWRUP_N_1V8 LELO_GR02_0.OSCILLATOR_0.PWRUP_B_1V8 0.73578f
C126 LELO_GR02_0.OSCILLATOR_0.x6.CK LELO_GR02_0.OSCILLATOR_0.x13<2>.B 0.55125f
C127 a_17426_6526# a_17426_6366# 0.15007f
C128 LELO_GR02_0.OSCILLATOR_0.x5.x11.G a_17682_11115# 0.03425f
C129 LELO_GR02_0.OSCILLATOR_0.x5.x9<4>.D a_18932_12714# 0.03624f
C130 LELO_GR02_0.BANDGAP_0.x5.A a_9590_12262# 0.05615f
C131 LELO_GR02_0.BANDGAP_0.x2.x2.P a_5506_11266# 0.16162f
C132 LELO_GR02_0.OSCILLATOR_0.PWRUP_N_1V8 a_3635_9859# 0.03597f
C133 LELO_GR02_0.OSCILLATOR_0.x6.XA7.CN LELO_GR02_0.OSCILLATOR_0.x6.XA4.MP1.S 0.02318f
C134 LELO_GR02_0.OSCILLATOR_0.x6.XA7.C a_20745_9895# 0.06576f
C135 a_17682_14700# VDPWR 0.47091f
C136 a_21585_10695# LELO_GR02_0.OSCILLATOR_0.x6.XA5.A 0.05912f
C137 a_20745_10695# a_20745_10375# 0.01f
C138 a_7758_18706# a_7758_18196# 0.02008f
C139 LELO_GR02_0.OSCILLATOR_0.PWRUP_N_1V8 a_8598_18196# 0.05997f
C140 LELO_GR02_0.OSCILLATOR_0.PWRUP_N_1V8 a_18932_6526# 0.08371f
C141 a_16245_12065# LELO_GR02_0.OSCILLATOR_0.x13<2>.B 0.01323f
C142 LELO_GR02_0.OSCILLATOR_0.PWRUP_B_1V8 LELO_GR02_0.OSCILLATOR_0.x6.XA6.A 0.05865f
C143 LELO_GR02_0.OSCILLATOR_0.V_CTAT a_12974_9428# 0.04613f
C144 a_9590_10745# a_9590_10585# 0.0971f
C145 LELO_GR02_0.OSCILLATOR_0.x5.x7.G a_17426_7006# 0.0375f
C146 uo_out<3> uo_out<2> 0.03102f
C147 LELO_GR02_0.OSCILLATOR_0.x5.x11.G LELO_GR02_0.OSCILLATOR_0.I_PTAT 0.86577f
C148 a_7269_13936# LELO_GR02_0.BANDGAP_0.x5.B 0.01587f
C149 LELO_GR02_0.BANDGAP_0.x2.x2<1>.A LELO_GR02_0.OSCILLATOR_0.V_CTAT 0.4253f
C150 LELO_GR02_0.BANDGAP_0.x5.A a_9590_12422# 0.04894f
C151 LELO_GR02_0.BANDGAP_0.x2.x2.P a_7268_12066# 0.14813f
C152 LELO_GR02_0.OSCILLATOR_0.x6.XA6.A a_21585_10375# 0.01281f
C153 a_18932_15500# VDPWR 0.51463f
C154 a_20745_10695# LELO_GR02_0.OSCILLATOR_0.x6.XA5.A 0.06582f
C155 a_20158_2966# a_20590_2966# 0.01515f
C156 LELO_GR02_0.OSCILLATOR_0.PWRUP_N_1V8 a_7758_18196# 0.09584f
C157 a_12974_9428# LELO_GR02_0.OSCILLATOR_0.x13<2>.B 0.02027f
C158 a_16245_12065# LELO_GR02_0.OSCILLATOR_0.x6.CK 0.07098f
C159 LELO_GR02_0.OSCILLATOR_0.x5.x9<4>.D a_18932_13514# 0.03483f
C160 a_3743_10332# a_3635_9859# 0.03655f
C161 a_7268_11132# a_7268_10332# 0.01761f
C162 LELO_GR02_0.OSCILLATOR_0.x5.x11.G a_17682_11915# 0.03428f
C163 LELO_GR02_0.OSCILLATOR_0.x5.x7.G a_17426_7122# 0.05013f
C164 LELO_GR02_0.BANDGAP_0.x2.x2<1>.A LELO_GR02_0.BANDGAP_0.x5.B 25.7049f
C165 LELO_GR02_0.BANDGAP_0.x2.x2.P a_3743_11266# 0.1481f
C166 LELO_GR02_0.OSCILLATOR_0.x5.x11.G VDPWR 3.78215f
C167 LELO_GR02_0.OSCILLATOR_0.PWRUP_N_1V8 a_17426_6526# 0.08443f
C168 LELO_GR02_0.OSCILLATOR_0.PWRUP_B_1V8 a_21585_11175# 0.06129f
C169 LELO_GR02_0.OSCILLATOR_0.V_CTAT a_12542_9428# 0.01501f
C170 a_18932_14700# a_18932_14314# 0.03892f
C171 LELO_GR02_0.BANDGAP_0.x4.D a_6392_9860# 0.08329f
C172 LELO_GR02_0.OSCILLATOR_0.x5.x7.G a_17426_7282# 0.03805f
C173 a_18932_8056# a_18932_7922# 0.12516f
C174 uo_out<4> uo_out<3> 0.03102f
C175 LELO_GR02_0.BANDGAP_0.x2.x2<1>.A a_5507_13136# 0.03711f
C176 LELO_GR02_0.BANDGAP_0.x5.A a_9590_12661# 0.03813f
C177 LELO_GR02_0.BANDGAP_0.x2.x2.P a_5506_12066# 0.16021f
C178 LELO_GR02_0.OSCILLATOR_0.x6.XA6.A LELO_GR02_0.OSCILLATOR_0.x6.XA5.A 0.22909f
C179 a_17682_15500# VDPWR 0.51211f
C180 a_8598_19026# a_8598_18706# 0.01f
C181 LELO_GR02_0.OSCILLATOR_0.PWRUP_N_1V8 a_7758_18706# 0.01351f
C182 LELO_GR02_0.BANDGAP_0.x2.x2.P a_6491_5710# 0.28135f
C183 a_20984_6987# a_20984_6827# 0.15007f
C184 a_18932_7006# a_18932_6526# 0.02114f
C185 LELO_GR02_0.OSCILLATOR_0.PWRUP_B_1V8 a_20745_11175# 0.06699f
C186 LELO_GR02_0.OSCILLATOR_0.x5.x11.G a_17682_12715# 0.03428f
C187 LELO_GR02_0.OSCILLATOR_0.x5.x9<4>.D a_18932_14314# 0.03702f
C188 LELO_GR02_0.BANDGAP_0.x2.x2<1>.A a_7269_13936# 0.07439f
C189 LELO_GR02_0.BANDGAP_0.x5.A a_9590_12821# 0.05646f
C190 LELO_GR02_0.BANDGAP_0.x2.x2.P a_3743_12066# 0.1481f
C191 LELO_GR02_0.OSCILLATOR_0.PWRUP_N_1V8 a_5506_10332# 0.01516f
C192 LELO_GR02_0.BANDGAP_0.x2.LELOATR_PCH_12C5F0_7.G LELO_GR02_0.OSCILLATOR_0.V_CTAT 0.36063f
C193 LELO_GR02_0.OSCILLATOR_0.x6.XA6.A a_21585_10695# 0.09795f
C194 LELO_GR02_0.BANDGAP_0.x2.LELOATR_PCH_12C5F0_7.G m1_5524_9447# 0.21849f
C195 a_8748_14798# VDPWR 0.66319f
C196 LELO_GR02_0.OSCILLATOR_0.PWRUP_N_1V8 a_20984_6987# 0.08081f
C197 LELO_GR02_0.OSCILLATOR_0.x5.x9<4>.D LELO_GR02_0.OSCILLATOR_0.x5.x9<4>.S 1.99743f
C198 uo_out<5> uo_out<4> 0.03102f
C199 LELO_GR02_0.BANDGAP_0.x2.LELOATR_PCH_12C5F0_7.G LELO_GR02_0.BANDGAP_0.x5.B 0.05496f
C200 LELO_GR02_0.BANDGAP_0.x5.A LELO_GR02_0.OSCILLATOR_0.I_PTAT 1.47898f
C201 a_5507_13936# a_5507_13136# 0.01761f
C202 LELO_GR02_0.OSCILLATOR_0.x6.XA6.A a_20745_10695# 0.0777f
C203 a_8748_14958# VDPWR 0.66141f
C204 LELO_GR02_0.OSCILLATOR_0.x6.CK a_21585_8615# 0.0615f
C205 a_7758_19026# a_7758_18706# 0.01f
C206 a_8598_19026# LELO_GR02_0.OSCILLATOR_0.PWRUP_N_1V8 0.01772f
C207 LELO_GR02_0.OSCILLATOR_0.PWRUP_N_1V8 a_20984_7467# 0.08111f
C208 a_20984_7467# a_20984_6987# 0.02114f
C209 LELO_GR02_0.OSCILLATOR_0.PWRUP_B_1V8 LELO_GR02_0.OSCILLATOR_0.x6.XA7.MP2.S 0.04378f
C210 LELO_GR02_0.OSCILLATOR_0.x5.x11.G a_17682_13515# 0.03436f
C211 a_17682_8056# a_17426_7922# 0.14791f
C212 ui_in<0> rst_n 0.03102f
C213 a_9590_14354# LELO_GR02_0.OSCILLATOR_0.V_CTAT 0.02923f
C214 LELO_GR02_0.BANDGAP_0.x2.LELOATR_PCH_12C5F0_7.G a_5507_13136# 0.07575f
C215 LELO_GR02_0.OSCILLATOR_0.PWRUP_N_1V8 a_3743_10332# 0.01566f
C216 LELO_GR02_0.OSCILLATOR_0.x6.XA7.CN LELO_GR02_0.OSCILLATOR_0.x6.XA4.MN1.S 0.03049f
C217 LELO_GR02_0.BANDGAP_0.x5.A VDPWR 3.00503f
C218 LELO_GR02_0.OSCILLATOR_0.x6.CK a_20745_8615# 0.0634f
C219 a_7758_19026# LELO_GR02_0.OSCILLATOR_0.PWRUP_N_1V8 0.01772f
C220 a_12542_9428# a_12974_9428# 0.01515f
C221 a_21585_9095# VDPWR 0.32808f
C222 a_5506_11132# a_5506_10332# 0.01761f
C223 LELO_GR02_0.OSCILLATOR_0.V_CTAT a_12110_9428# 0.01776f
C224 a_17682_14700# a_17682_14315# 0.03904f
C225 LELO_GR02_0.BANDGAP_0.x4.D LELO_GR02_0.BANDGAP_0.x2.LELOATR_NCH_4C5F0_5.D 0.64175f
C226 LELO_GR02_0.OSCILLATOR_0.PWRUP_B_1V8 LELO_GR02_0.OSCILLATOR_0.x6.XA7.CN 0.11034f
C227 uo_out<6> uo_out<5> 0.03102f
C228 ui_in<0> ui_in<1> 0.03354f
C229 a_9590_14514# LELO_GR02_0.OSCILLATOR_0.V_CTAT 0.01027f
C230 a_9590_14354# LELO_GR02_0.BANDGAP_0.x5.B 0.08074f
C231 a_5507_13936# LELO_GR02_0.BANDGAP_0.x2.x2<1>.A 0.03399f
C232 LELO_GR02_0.BANDGAP_0.x2.x2.P a_7268_12200# 0.1481f
C233 LELO_GR02_0.OSCILLATOR_0.x6.XA7.CN a_21585_10375# 0.02605f
C234 a_8748_15438# VDPWR 0.66783f
C235 a_19726_2966# a_20158_2966# 0.14233f
C236 LELO_GR02_0.BANDGAP_0.x2.x2.P a_6059_5710# 0.02579f
C237 LELO_GR02_0.OSCILLATOR_0.PWRUP_N_1V8 a_18932_7006# 0.08978f
C238 a_20984_7627# a_20984_7467# 0.15007f
C239 LELO_GR02_0.OSCILLATOR_0.x5.x11.G LELO_GR02_0.OSCILLATOR_0.x5.x9<4>.S 3.04304f
C240 LELO_GR02_0.OSCILLATOR_0.PWRUP_B_1V8 LELO_GR02_0.OSCILLATOR_0.x6.XA7.C 0.47807f
C241 a_11030_9428# VDPWR 0.05235f
C242 a_21585_8615# a_21585_8295# 0.01f
C243 LELO_GR02_0.BANDGAP_0.x2.LELOATR_PCH_12C5F0_7.G LELO_GR02_0.BANDGAP_0.x2.x2<1>.A 2.42363f
C244 LELO_GR02_0.OSCILLATOR_0.x6.CK a_18932_8056# 0.03385f
C245 LELO_GR02_0.OSCILLATOR_0.x6.XA7.C a_21585_10375# 0.06664f
C246 LELO_GR02_0.OSCILLATOR_0.x6.XA7.CN a_20745_10375# 0.08881f
C247 a_8748_15598# VDPWR 0.65066f
C248 LELO_GR02_0.OSCILLATOR_0.PWRUP_N_1V8 a_18932_7122# 0.05088f
C249 a_17426_7006# a_17426_6526# 0.02114f
C250 a_21585_9415# VDPWR 0.31316f
C251 LELO_GR02_0.OSCILLATOR_0.x5.x11.S a_20567_12681# 0.05639f
C252 LELO_GR02_0.OSCILLATOR_0.x5.x11.G a_17682_14315# 0.04072f
C253 uo_out<7> uo_out<6> 0.03102f
C254 LELO_GR02_0.OSCILLATOR_0.PWRUP_B_1V8 LELO_GR02_0.BANDGAP_0.x4.D 0.16274f
C255 LELO_GR02_0.BANDGAP_0.x2.LELOATR_PCH_12C5F0_7.G a_3744_13136# 0.11503f
C256 LELO_GR02_0.OSCILLATOR_0.x6.XA7.CN LELO_GR02_0.OSCILLATOR_0.x6.XA5.A 0.38708f
C257 a_5664_14810# VDPWR 0.52758f
C258 LELO_GR02_0.OSCILLATOR_0.PWRUP_N_1V8 a_18932_7282# 0.09016f
C259 LELO_GR02_0.OSCILLATOR_0.x5.x11.S a_20567_13481# 0.07433f
C260 a_3743_11132# a_3743_10332# 0.01761f
C261 a_20745_8615# a_20745_8295# 0.01f
C262 a_3744_13936# a_3744_13136# 0.01761f
C263 LELO_GR02_0.BANDGAP_0.x2.LELOATR_PCH_12C5F0_7.G a_5507_13936# 0.07439f
C264 LELO_GR02_0.BANDGAP_0.x2.x6.D a_6491_5710# 0.02283f
C265 LELO_GR02_0.OSCILLATOR_0.x6.CK a_18932_8856# 0.01016f
C266 LELO_GR02_0.OSCILLATOR_0.x6.XA7.C LELO_GR02_0.OSCILLATOR_0.x6.XA5.A 0.08968f
C267 LELO_GR02_0.OSCILLATOR_0.x6.XA7.CN a_21585_10695# 0.026f
C268 a_5664_14970# VDPWR 0.65536f
C269 LELO_GR02_0.OSCILLATOR_0.PWRUP_N_1V8 a_17426_7006# 0.09035f
C270 LELO_GR02_0.OSCILLATOR_0.x6.XA3.MP1.S VDPWR 0.09448f
C271 LELO_GR02_0.OSCILLATOR_0.PWRUP_B_1V8 LELO_GR02_0.OSCILLATOR_0.x6.D 0.07994f
C272 LELO_GR02_0.OSCILLATOR_0.V_CTAT a_11678_9428# 0.02189f
C273 LELO_GR02_0.OSCILLATOR_0.x5.x9<4>.D LELO_GR02_0.OSCILLATOR_0.x6.CK 0.77945f
C274 a_7023_7969# a_7023_7834# 0.14629f
C275 uio_out<0> uo_out<7> 0.03102f
C276 LELO_GR02_0.BANDGAP_0.x5.A a_9590_13301# 0.05648f
C277 LELO_GR02_0.BANDGAP_0.x2.x2.P a_5506_12200# 0.16014f
C278 LELO_GR02_0.BANDGAP_0.x2.x2.P VDPWR 7.97912f
C279 LELO_GR02_0.OSCILLATOR_0.x6.XA7.CN a_20745_10695# 0.02661f
C280 LELO_GR02_0.OSCILLATOR_0.PWRUP_N_1V8 a_17426_7122# 0.05348f
C281 LELO_GR02_0.BANDGAP_0.x5.B a_7023_7969# 0.03205f
C282 a_18932_7122# a_18932_7006# 0.24178f
C283 a_7268_11266# a_7268_11132# 0.23893f
C284 a_3744_13936# LELO_GR02_0.BANDGAP_0.x2.LELOATR_PCH_12C5F0_7.G 0.10297f
C285 LELO_GR02_0.BANDGAP_0.x5.A a_9590_13461# 0.03666f
C286 LELO_GR02_0.BANDGAP_0.x2.x2.P a_7268_13000# 0.14855f
C287 LELO_GR02_0.OSCILLATOR_0.x5.x11.G LELO_GR02_0.OSCILLATOR_0.V_CTAT 1.86459f
C288 a_5664_15450# VDPWR 0.66844f
C289 LELO_GR02_0.OSCILLATOR_0.x6.XA7.CN LELO_GR02_0.OSCILLATOR_0.x6.XA6.MP1.S 0.02377f
C290 a_18932_10314# a_18323_10035# 0.01518f
C291 a_28996_21150# a_28996_20830# 0.01f
C292 LELO_GR02_0.OSCILLATOR_0.PWRUP_N_1V8 a_17426_7282# 0.09576f
C293 a_12110_9428# a_12542_9428# 0.14233f
C294 a_21585_9895# VDPWR 0.31321f
C295 LELO_GR02_0.OSCILLATOR_0.x5.x11.G LELO_GR02_0.OSCILLATOR_0.x13<2>.B 0.02587f
C296 a_7642_9858# VDPWR 0.01997f
C297 uio_out<1> uio_out<0> 0.03102f
C298 LELO_GR02_0.BANDGAP_0.x2.x2.P a_3743_12200# 0.1481f
C299 a_5664_15610# VDPWR 0.66789f
C300 LELO_GR02_0.OSCILLATOR_0.x6.XA7.C LELO_GR02_0.OSCILLATOR_0.x6.XA6.MP1.S 0.02158f
C301 LELO_GR02_0.OSCILLATOR_0.x6.D LELO_GR02_0.OSCILLATOR_0.x6.XA5.A 0.03009f
C302 LELO_GR02_0.OSCILLATOR_0.x6.XA7.CN LELO_GR02_0.OSCILLATOR_0.x6.XA6.A 0.66396f
C303 a_19510_4886# a_19942_4886# 0.21349f
C304 LELO_GR02_0.BANDGAP_0.x5.B a_7023_8769# 0.0438f
C305 a_18932_7282# a_18932_7122# 0.24178f
C306 LELO_GR02_0.BANDGAP_0.x4.D a_5506_10332# 0.02413f
C307 LELO_GR02_0.OSCILLATOR_0.x5.x11.G LELO_GR02_0.OSCILLATOR_0.x6.CK 0.1954f
C308 a_5773_7970# a_5773_7835# 0.14629f
C309 LELO_GR02_0.BANDGAP_0.x5.A a_9590_13714# 0.0361f
C310 LELO_GR02_0.BANDGAP_0.x2.x2.P a_5506_13000# 0.1628f
C311 LELO_GR02_0.OSCILLATOR_0.PWRUP_N_1V8 LELO_GR02_0.BANDGAP_0.x4.D 0.08792f
C312 LELO_GR02_0.OSCILLATOR_0.x5.x11.S uo_out<0> 0.20285f
C313 a_18185_16201# VDPWR 0.63215f
C314 LELO_GR02_0.OSCILLATOR_0.x6.XA7.CN LELO_GR02_0.OSCILLATOR_0.x6.XA6.MN1.S 0.03056f
C315 LELO_GR02_0.OSCILLATOR_0.x6.XA7.C LELO_GR02_0.OSCILLATOR_0.x6.XA6.A 0.58714f
C316 LELO_GR02_0.BANDGAP_0.x2.x6.D a_6059_5710# 0.01934f
C317 LELO_GR02_0.OSCILLATOR_0.x6.XA7.MP2.S a_21585_11175# 0.0183f
C318 a_28156_21150# a_28156_20830# 0.01f
C319 LELO_GR02_0.OSCILLATOR_0.x6.XA4.MP1.S VDPWR 0.09448f
C320 a_9590_11385# a_9590_11225# 0.0971f
C321 LELO_GR02_0.OSCILLATOR_0.V_CTAT a_11246_9428# 0.02814f
C322 a_6392_9860# VDPWR 0.02853f
C323 uio_out<2> uio_out<1> 0.03102f
C324 LELO_GR02_0.OSCILLATOR_0.x5.x11.S LELO_GR02_0.OSCILLATOR_0.I_PTAT 0.84898f
C325 LELO_GR02_0.BANDGAP_0.x5.A a_9590_13874# 0.05607f
C326 LELO_GR02_0.BANDGAP_0.x2.x2.P a_3743_13000# 0.14787f
C327 a_18185_16361# VDPWR 0.66337f
C328 LELO_GR02_0.OSCILLATOR_0.x6.XA7.C LELO_GR02_0.OSCILLATOR_0.x6.XA6.MN1.S 0.01275f
C329 LELO_GR02_0.OSCILLATOR_0.x6.XA7.CN a_21585_11175# 0.02572f
C330 a_19294_2966# a_19726_2966# 0.14233f
C331 LELO_GR02_0.BANDGAP_0.x2.x2.P a_7023_7034# 0.01397f
C332 LELO_GR02_0.BANDGAP_0.x5.A LELO_GR02_0.OSCILLATOR_0.V_CTAT 0.88655f
C333 a_9590_14514# a_9590_14354# 0.0971f
C334 LELO_GR02_0.OSCILLATOR_0.x5.x11.S VDPWR 7.7103f
C335 LELO_GR02_0.OSCILLATOR_0.x6.XA7.C a_21585_11175# 0.06949f
C336 LELO_GR02_0.OSCILLATOR_0.x6.XA7.CN a_20745_11175# 0.06325f
C337 LELO_GR02_0.OSCILLATOR_0.x6.D LELO_GR02_0.OSCILLATOR_0.x6.XA6.MP1.S 0.04373f
C338 LELO_GR02_0.OSCILLATOR_0.x6.XA7.MP2.S LELO_GR02_0.OSCILLATOR_0.x6.XA7.MN2.D 0.05173f
C339 JNWTR_TIEL_CV_0.MP0.G a_28996_21150# 0.06636f
C340 LELO_GR02_0.BANDGAP_0.x4.D a_5506_11132# 0.01811f
C341 LELO_GR02_0.OSCILLATOR_0.V_CTAT LELO_GR02_0.BANDGAP_0.x8.DN 2.89478f
C342 a_4521_7969# a_4521_7834# 0.14629f
C343 uio_out<3> uio_out<2> 0.03102f
C344 LELO_GR02_0.BANDGAP_0.x5.A LELO_GR02_0.BANDGAP_0.x5.B 5.09878f
C345 a_18185_16841# VDPWR 0.65433f
C346 LELO_GR02_0.OSCILLATOR_0.x6.XA7.C a_20745_11175# 0.01225f
C347 LELO_GR02_0.OSCILLATOR_0.x6.D LELO_GR02_0.OSCILLATOR_0.x6.XA6.A 0.08816f
C348 JNWTR_TIEL_CV_0.MP0.G a_28156_21150# 0.05912f
C349 LELO_GR02_0.OSCILLATOR_0.I_PTAT a_15861_9786# 0.0281f
C350 a_17426_7122# a_17426_7006# 0.24178f
C351 a_5506_11266# a_5506_11132# 0.23893f
C352 a_9590_11622# a_9590_11385# 0.05836f
C353 LELO_GR02_0.BANDGAP_0.x5.B LELO_GR02_0.BANDGAP_0.x8.DN 0.42252f
C354 LELO_GR02_0.OSCILLATOR_0.V_CTAT a_11030_9428# 0.03408f
C355 LELO_GR02_0.BANDGAP_0.x2.x2.P a_7269_13136# 0.14849f
C356 a_18185_17001# VDPWR 0.51722f
C357 LELO_GR02_0.OSCILLATOR_0.x6.XA7.CN LELO_GR02_0.OSCILLATOR_0.x6.XA7.MP2.S 0.07161f
C358 LELO_GR02_0.BANDGAP_0.x2.x6.D a_5627_5710# 0.24398f
C359 LELO_GR02_0.OSCILLATOR_0.x6.D LELO_GR02_0.OSCILLATOR_0.x6.XA6.MN1.S 0.05588f
C360 a_28996_21470# a_28996_21150# 0.01f
C361 a_11894_11348# a_12326_11348# 0.21349f
C362 LELO_GR02_0.OSCILLATOR_0.I_PTAT a_15861_9946# 0.01753f
C363 LELO_GR02_0.BANDGAP_0.x2.LELOATR_NCH_4C5F0_5.D VDPWR 0.03216f
C364 uio_out<4> uio_out<3> 0.03102f
C365 LELO_GR02_0.OSCILLATOR_0.PWRUP_B_1V8 uo_out<0> 0.26095f
C366 a_8598_17876# VDPWR 0.28368f
C367 LELO_GR02_0.OSCILLATOR_0.x6.XA7.C LELO_GR02_0.OSCILLATOR_0.x6.XA7.MP2.S 0.04215f
C368 LELO_GR02_0.OSCILLATOR_0.x6.D a_21585_11175# 0.02572f
C369 JNWTR_TIEL_CV_0.Y JNWTR_TIEL_CV_0.MP0.G 0.01589f
C370 a_17426_7282# a_17426_7122# 0.24178f
C371 LELO_GR02_0.BANDGAP_0.x5.B a_7642_9058# 0.01954f
C372 a_5141_9860# VDPWR 0.0256f
C373 uo_out<0> uio_in<7> 0.03102f
C374 LELO_GR02_0.OSCILLATOR_0.x5.x9<4>.D a_18932_14700# 0.03705f
C375 LELO_GR02_0.BANDGAP_0.x5.A LELO_GR02_0.BANDGAP_0.x2.x2<1>.A 0.03399f
C376 LELO_GR02_0.OSCILLATOR_0.PWRUP_B_1V8 LELO_GR02_0.OSCILLATOR_0.I_PTAT 1.40363f
C377 LELO_GR02_0.OSCILLATOR_0.x6.D a_20745_11175# 0.03052f
C378 LELO_GR02_0.OSCILLATOR_0.x6.XA7.C LELO_GR02_0.OSCILLATOR_0.x6.XA7.CN 0.47812f
C379 a_28156_21470# a_28156_21150# 0.01f
C380 a_28996_21470# JNWTR_TIEL_CV_0.MP0.G 0.08348f
C381 LELO_GR02_0.BANDGAP_0.x2.x2.P a_5773_7035# 0.01743f
C382 a_11678_9428# a_12110_9428# 0.14233f
C383 a_3743_11266# a_3743_11132# 0.23893f
C384 a_9590_11782# a_9590_11622# 0.0971f
C385 LELO_GR02_0.BANDGAP_0.x2.x2<1>.A LELO_GR02_0.BANDGAP_0.x8.DN 2.14959f
C386 LELO_GR02_0.BANDGAP_0.x5.B a_7642_9218# 0.04675f
C387 uio_out<5> uio_out<4> 0.03102f
C388 uo_out<0> uo_out<1> 0.03215f
C389 LELO_GR02_0.BANDGAP_0.x2.x2.P LELO_GR02_0.OSCILLATOR_0.V_CTAT 0.25938f
C390 LELO_GR02_0.OSCILLATOR_0.PWRUP_B_1V8 VDPWR 1.15967f
C391 LELO_GR02_0.BANDGAP_0.x2.x6.D a_5195_3790# 0.02126f
C392 LELO_GR02_0.OSCILLATOR_0.x6.D LELO_GR02_0.OSCILLATOR_0.x6.XA7.MN2.D 0.01878f
C393 a_21585_11815# LELO_GR02_0.OSCILLATOR_0.x6.XA7.CN 0.06207f
C394 LELO_GR02_0.OSCILLATOR_0.x5.x9<4>.S a_18323_9235# 0.01351f
C395 a_19078_4886# a_19510_4886# 0.21349f
C396 a_28156_21470# JNWTR_TIEL_CV_0.MP0.G 0.06129f
C397 a_21585_10375# VDPWR 0.30908f
C398 LELO_GR02_0.BANDGAP_0.x4.D a_9590_11622# 0.01342f
C399 LELO_GR02_0.OSCILLATOR_0.x5.x11.S LELO_GR02_0.OSCILLATOR_0.x5.x9<4>.S 1.50749f
C400 LELO_GR02_0.OSCILLATOR_0.V_CTAT a_7642_9698# 0.01265f
C401 a_3635_9859# VDPWR 0.01678f
C402 LELO_GR02_0.BANDGAP_0.x2.x2.P LELO_GR02_0.BANDGAP_0.x5.B 2.25925f
C403 a_8598_18196# VDPWR 0.28269f
C404 LELO_GR02_0.BANDGAP_0.x2.x6.D a_7023_7034# 0.08399f
C405 LELO_GR02_0.OSCILLATOR_0.x6.D LELO_GR02_0.OSCILLATOR_0.x6.XA7.MP2.S 0.33356f
C406 LELO_GR02_0.OSCILLATOR_0.x5.x9<4>.S LELO_GR02_0.OSCILLATOR_0.x5.x7.G 0.39882f
C407 a_28156_21470# JNWTR_TIEL_CV_0.Y 0.03751f
C408 a_7268_12066# a_7268_11266# 0.01761f
C409 LELO_GR02_0.BANDGAP_0.x4.D a_9590_11782# 0.03093f
C410 LELO_GR02_0.OSCILLATOR_0.I_PTAT a_9590_10585# 0.01076f
C411 LELO_GR02_0.OSCILLATOR_0.V_CTAT a_7642_9858# 0.0246f
C412 LELO_GR02_0.BANDGAP_0.x5.B a_7642_9698# 0.06013f
C413 a_7268_10332# VDPWR 0.69061f
C414 LELO_GR02_0.OSCILLATOR_0.x5.x7.G a_18932_7922# 0.01111f
C415 uio_out<6> uio_out<5> 0.03102f
C416 a_18932_15500# LELO_GR02_0.OSCILLATOR_0.x5.x9<4>.D 0.013f
C417 LELO_GR02_0.OSCILLATOR_0.x5.x11.G a_18932_14700# 0.07169f
C418 LELO_GR02_0.BANDGAP_0.x2.x2.P a_5507_13136# 0.16282f
C419 LELO_GR02_0.OSCILLATOR_0.x6.D LELO_GR02_0.OSCILLATOR_0.x6.XA7.CN 0.4483f
C420 a_20745_11815# LELO_GR02_0.OSCILLATOR_0.x6.XA7.C 0.06698f
C421 a_8598_18706# ui_in<0> 0.06129f
C422 LELO_GR02_0.OSCILLATOR_0.x5.x9<4>.S a_18323_10035# 0.04365f
C423 a_18862_2966# a_19294_2966# 0.14233f
C424 LELO_GR02_0.OSCILLATOR_0.x6.XA5.A VDPWR 0.66668f
C425 LELO_GR02_0.OSCILLATOR_0.I_PTAT a_9590_10745# 0.029f
C426 LELO_GR02_0.OSCILLATOR_0.V_CTAT a_5141_9060# 0.06933f
C427 LELO_GR02_0.BANDGAP_0.x5.B a_7642_9858# 0.04864f
C428 LELO_GR02_0.OSCILLATOR_0.x5.x7.G a_17426_7762# 0.0404f
C429 a_9590_10585# VDPWR 0.33489f
C430 uo_out<0> uo_out<4> 0.01223f
C431 LELO_GR02_0.OSCILLATOR_0.x5.x11.G LELO_GR02_0.OSCILLATOR_0.x5.x9<4>.D 0.38801f
C432 LELO_GR02_0.BANDGAP_0.x2.x2.P a_7269_13936# 0.14872f
C433 LELO_GR02_0.OSCILLATOR_0.x6.D LELO_GR02_0.OSCILLATOR_0.x6.XA7.C 0.77637f
C434 a_8598_18706# VDPWR 0.29586f
C435 a_7758_18706# ui_in<0> 0.06092f
C436 a_21585_10695# VDPWR 0.30912f
C437 a_6707_3790# a_7139_3790# 0.01515f
C438 a_5506_11266# LELO_GR02_0.BANDGAP_0.x4.D 0.01827f
C439 LELO_GR02_0.OSCILLATOR_0.V_CTAT a_6392_9860# 0.01542f
C440 LELO_GR02_0.BANDGAP_0.x2.x2<1>.A a_6392_9060# 0.01029f
C441 LELO_GR02_0.OSCILLATOR_0.x5.x7.G a_17426_7922# 0.03459f
C442 a_9590_10745# VDPWR 0.35531f
C443 uio_out<7> uio_out<6> 0.03102f
C444 LELO_GR02_0.OSCILLATOR_0.PWRUP_N_1V8 LELO_GR02_0.OSCILLATOR_0.I_PTAT 2.72599f
C445 a_5664_14810# a_5507_13936# 0.01049f
C446 LELO_GR02_0.OSCILLATOR_0.x5.x11.G a_17682_14700# 0.11676f
C447 LELO_GR02_0.BANDGAP_0.x5.A a_9590_14354# 0.05631f
C448 LELO_GR02_0.BANDGAP_0.x2.x2.P LELO_GR02_0.BANDGAP_0.x2.x2<1>.A 6.01045f
C449 LELO_GR02_0.OSCILLATOR_0.x6.D a_21585_11815# 0.08594f
C450 LELO_GR02_0.OSCILLATOR_0.PWRUP_N_1V8 ui_in<0> 0.14929f
C451 LELO_GR02_0.OSCILLATOR_0.x6.XA6.A uo_out<0> 0.01049f
C452 a_7268_12066# LELO_GR02_0.BANDGAP_0.x4.D 0.0319f
C453 a_5506_10332# VDPWR 0.69122f
C454 LELO_GR02_0.OSCILLATOR_0.x5.x11.G a_18932_15500# 0.07043f
C455 LELO_GR02_0.BANDGAP_0.x5.A a_9590_14514# 0.03533f
C456 LELO_GR02_0.BANDGAP_0.x2.x2.P a_3744_13136# 0.14782f
C457 LELO_GR02_0.OSCILLATOR_0.x5.x11.S LELO_GR02_0.OSCILLATOR_0.V_CTAT 0.04764f
C458 a_21585_12135# a_21585_11815# 0.01f
C459 LELO_GR02_0.OSCILLATOR_0.PWRUP_N_1V8 VDPWR 7.5998f
C460 a_8598_19026# ui_in<0> 0.06192f
C461 LELO_GR02_0.OSCILLATOR_0.x6.D a_20745_11815# 0.11369f
C462 a_11462_11348# a_11894_11348# 0.21349f
C463 LELO_GR02_0.OSCILLATOR_0.x6.XA6.MP1.S VDPWR 0.08476f
C464 LELO_GR02_0.OSCILLATOR_0.PWRUP_B_1V8 LELO_GR02_0.OSCILLATOR_0.x5.x9<4>.S 0.3855f
C465 LELO_GR02_0.OSCILLATOR_0.x5.x11.S LELO_GR02_0.OSCILLATOR_0.x13<2>.B 0.03055f
C466 a_7268_11132# VDPWR 0.67199f
C467 uio_oe<0> uio_out<7> 0.03102f
C468 LELO_GR02_0.BANDGAP_0.x2.x2.P a_5507_13936# 0.168f
C469 a_8598_19026# VDPWR 0.34013f
C470 a_7758_19026# ui_in<0> 0.11365f
C471 LELO_GR02_0.BANDGAP_0.x2.x6.D a_5773_7035# 0.08293f
C472 a_15861_10426# a_15861_9946# 0.02114f
C473 LELO_GR02_0.OSCILLATOR_0.x5.x7.G a_20590_2966# 0.01634f
C474 LELO_GR02_0.OSCILLATOR_0.x6.XA6.A VDPWR 1.27634f
C475 a_5506_12066# LELO_GR02_0.BANDGAP_0.x4.D 0.03047f
C476 LELO_GR02_0.OSCILLATOR_0.x5.x11.S LELO_GR02_0.OSCILLATOR_0.x6.CK 0.89646f
C477 LELO_GR02_0.OSCILLATOR_0.V_CTAT LELO_GR02_0.BANDGAP_0.x2.x6.D 0.0139f
C478 a_3743_10332# VDPWR 0.69044f
C479 a_17682_15500# LELO_GR02_0.OSCILLATOR_0.x5.x11.G 0.08437f
C480 LELO_GR02_0.BANDGAP_0.x2.x2.P LELO_GR02_0.BANDGAP_0.x2.LELOATR_PCH_12C5F0_7.G 9.7746f
C481 LELO_GR02_0.BANDGAP_0.x2.LELOATR_NCH_4C5F0_5.D a_5773_7035# 0.013f
C482 LELO_GR02_0.BANDGAP_0.x2.x6.D a_7023_7834# 0.07665f
C483 a_21585_12135# LELO_GR02_0.OSCILLATOR_0.x6.D 0.11261f
C484 a_20745_12135# a_20745_11815# 0.01f
C485 LELO_GR02_0.OSCILLATOR_0.x6.CK LELO_GR02_0.OSCILLATOR_0.x5.x7.G 0.4479f
C486 a_11246_9428# a_11678_9428# 0.14233f
C487 a_5506_12066# a_5506_11266# 0.01761f
C488 LELO_GR02_0.BANDGAP_0.x5.B LELO_GR02_0.BANDGAP_0.x2.x6.D 1.01851f
C489 LELO_GR02_0.OSCILLATOR_0.V_CTAT LELO_GR02_0.BANDGAP_0.x2.LELOATR_NCH_4C5F0_5.D 0.82015f
C490 LELO_GR02_0.BANDGAP_0.x2.x2<1>.A a_6392_9860# 0.05053f
C491 LELO_GR02_0.OSCILLATOR_0.PWRUP_B_1V8 a_15861_10426# 0.08099f
C492 a_5506_11132# VDPWR 0.67191f
C493 LELO_GR02_0.BANDGAP_0.x2.LELOATR_NCH_4C5F0_5.D m1_5524_9447# 0.20586f
C494 uio_oe<1> uio_oe<0> 0.04467f
C495 LELO_GR02_0.BANDGAP_0.x2.x2.P a_3744_13936# 0.1481f
C496 a_28996_20830# VDPWR 0.36441f
C497 LELO_GR02_0.BANDGAP_0.x2.x6.D a_4521_7034# 0.11933f
C498 a_20745_12135# LELO_GR02_0.OSCILLATOR_0.x6.D 0.12534f
C499 LELO_GR02_0.OSCILLATOR_0.x13<2>.B a_15861_9786# 0.01102f
C500 a_18646_4886# a_19078_4886# 0.21349f
C501 a_21585_11175# VDPWR 0.29994f
C502 a_9590_12262# LELO_GR02_0.BANDGAP_0.x4.D 0.03913f
C503 LELO_GR02_0.OSCILLATOR_0.I_PTAT a_9590_11225# 0.03617f
C504 LELO_GR02_0.BANDGAP_0.x5.B LELO_GR02_0.BANDGAP_0.x2.LELOATR_NCH_4C5F0_5.D 0.26526f
C505 LELO_GR02_0.OSCILLATOR_0.V_CTAT a_5141_9860# 0.07946f
C506 LELO_GR02_0.OSCILLATOR_0.PWRUP_B_1V8 a_15861_10586# 0.01533f
C507 a_3743_11132# VDPWR 0.6712f
C508 LELO_GR02_0.BANDGAP_0.x2.x6.D a_5773_7835# 0.07665f
C509 LELO_GR02_0.OSCILLATOR_0.x13<2>.B a_15861_9946# 0.04535f
C510 LELO_GR02_0.OSCILLATOR_0.x6.XA7.MP2.S uo_out<0> 0.08106f
C511 a_6275_3790# a_6707_3790# 0.14233f
C512 a_9590_12422# LELO_GR02_0.BANDGAP_0.x4.D 0.01626f
C513 LELO_GR02_0.OSCILLATOR_0.I_PTAT a_9590_11385# 0.02183f
C514 LELO_GR02_0.BANDGAP_0.x2.LELOATR_PCH_12C5F0_7.G a_5141_9060# 0.01028f
C515 a_9590_11225# VDPWR 0.35583f
C516 uio_oe<2> uio_oe<1> 0.0484f
C517 LELO_GR02_0.OSCILLATOR_0.PWRUP_B_1V8 LELO_GR02_0.OSCILLATOR_0.V_CTAT 0.92937f
C518 a_28996_21150# VDPWR 0.39912f
C519 LELO_GR02_0.BANDGAP_0.x2.LELOATR_NCH_4C5F0_5.D a_5773_7835# 0.03089f
C520 LELO_GR02_0.BANDGAP_0.x2.x6.D a_4521_7834# 0.10878f
C521 a_18430_2966# a_18862_2966# 0.14233f
C522 LELO_GR02_0.OSCILLATOR_0.PWRUP_N_1V8 a_18932_7762# 0.08373f
C523 LELO_GR02_0.OSCILLATOR_0.x6.XA7.CN uo_out<0> 0.25685f
C524 a_7268_12200# LELO_GR02_0.BANDGAP_0.x4.D 0.03471f
C525 a_3743_12066# a_3743_11266# 0.01761f
C526 LELO_GR02_0.OSCILLATOR_0.PWRUP_N_1V8 LELO_GR02_0.OSCILLATOR_0.x5.x9<4>.S 0.72181f
C527 LELO_GR02_0.BANDGAP_0.x2.x2<1>.A LELO_GR02_0.BANDGAP_0.x2.x6.D 0.0832f
C528 LELO_GR02_0.OSCILLATOR_0.PWRUP_B_1V8 LELO_GR02_0.OSCILLATOR_0.x13<2>.B 1.24472f
C529 a_9590_11385# VDPWR 0.36916f
C530 a_8748_14958# a_8748_14798# 0.15007f
C531 JNWTR_TIEL_CV_0.Y uo_out<0> 1.20523f
C532 a_20567_12681# a_20745_12135# 0.01868f
C533 LELO_GR02_0.OSCILLATOR_0.x6.XA7.C uo_out<0> 0.15961f
C534 LELO_GR02_0.OSCILLATOR_0.x5.x7.G a_19942_4886# 0.47606f
C535 LELO_GR02_0.OSCILLATOR_0.x6.XA7.MP2.S VDPWR 0.28519f
C536 LELO_GR02_0.BANDGAP_0.x2.x2<1>.A LELO_GR02_0.BANDGAP_0.x2.LELOATR_NCH_4C5F0_5.D 0.42839f
C537 LELO_GR02_0.OSCILLATOR_0.PWRUP_B_1V8 LELO_GR02_0.OSCILLATOR_0.x6.CK 0.70499f
C538 LELO_GR02_0.OSCILLATOR_0.x6.CK a_18932_6366# 0.01021f
C539 a_7268_11266# VDPWR 0.67199f
C540 uio_oe<3> uio_oe<2> 0.04747f
C541 LELO_GR02_0.BANDGAP_0.x5.A a_8748_14798# 0.03616f
C542 JNWTR_TIEL_CV_0.Y ui_in<0> 2.06747f
C543 JNWTR_TIEL_CV_0.MP0.G VDPWR 0.57472f
C544 LELO_GR02_0.OSCILLATOR_0.PWRUP_N_1V8 a_17426_7762# 0.08988f
C545 LELO_GR02_0.BANDGAP_0.x8.DN a_11462_11348# 0.25648f
C546 a_21585_11815# uo_out<0> 0.02068f
C547 LELO_GR02_0.OSCILLATOR_0.x6.XA7.CN VDPWR 1.37331f
C548 clk ena 0.03102f
C549 a_7268_12200# a_7268_12066# 0.23893f
C550 LELO_GR02_0.OSCILLATOR_0.V_CTAT a_9590_10585# 0.01155f
C551 LELO_GR02_0.BANDGAP_0.x5.B a_7268_10332# 0.06758f
C552 LELO_GR02_0.OSCILLATOR_0.x6.CK a_18932_6526# 0.03815f
C553 a_9590_11622# VDPWR 0.36887f
C554 LELO_GR02_0.BANDGAP_0.x5.A a_8748_14958# 0.04055f
C555 JNWTR_TIEL_CV_0.Y VDPWR 0.03806f
C556 a_7642_9058# a_7023_8769# 0.01391f
C557 LELO_GR02_0.OSCILLATOR_0.PWRUP_N_1V8 a_17426_7922# 0.01402f
C558 LELO_GR02_0.BANDGAP_0.x8.DN a_11246_9428# 0.2077f
C559 LELO_GR02_0.OSCILLATOR_0.x6.XA7.C VDPWR 2.5971f
C560 LELO_GR02_0.BANDGAP_0.x2.LELOATR_PCH_12C5F0_7.G LELO_GR02_0.BANDGAP_0.x2.x6.D 0.0508f
C561 LELO_GR02_0.OSCILLATOR_0.PWRUP_B_1V8 a_12974_9428# 0.16302f
C562 LELO_GR02_0.OSCILLATOR_0.I_PTAT LELO_GR02_0.BANDGAP_0.x4.D 0.87018f
C563 LELO_GR02_0.BANDGAP_0.x5.B a_9590_10585# 0.01661f
C564 a_9590_11782# VDPWR 0.35554f
C565 uio_oe<4> uio_oe<3> 0.0456f
C566 a_8748_15438# a_8748_14958# 0.02114f
C567 a_28996_21470# VDPWR 0.28608f
C568 a_11030_9428# a_11246_9428# 0.01515f
C569 a_21585_11815# VDPWR 0.31129f
C570 LELO_GR02_0.OSCILLATOR_0.x6.D uo_out<0> 0.55155f
C571 rst_n clk 0.03102f
C572 LELO_GR02_0.BANDGAP_0.x5.A LELO_GR02_0.BANDGAP_0.x8.DN 0.02369f
C573 LELO_GR02_0.BANDGAP_0.x2.LELOATR_PCH_12C5F0_7.G LELO_GR02_0.BANDGAP_0.x2.LELOATR_NCH_4C5F0_5.D 0.2996f
C574 LELO_GR02_0.BANDGAP_0.x2.x2<1>.A a_3635_9859# 0.01098f
C575 a_5506_12200# LELO_GR02_0.BANDGAP_0.x4.D 0.02903f
C576 LELO_GR02_0.BANDGAP_0.x5.B a_9590_10745# 0.08336f
C577 LELO_GR02_0.BANDGAP_0.x4.D VDPWR 1.20964f
C578 LELO_GR02_0.OSCILLATOR_0.x5.x7.G a_18932_8056# 0.0719f
C579 a_8748_15438# LELO_GR02_0.BANDGAP_0.x5.A 0.03833f
C580 LELO_GR02_0.OSCILLATOR_0.PWRUP_N_1V8 LELO_GR02_0.OSCILLATOR_0.V_CTAT 1.31855f
C581 LELO_GR02_0.OSCILLATOR_0.PWRUP_N_1V8 m1_5524_9447# 0.01026f
C582 LELO_GR02_0.OSCILLATOR_0.x5.x7.G a_19510_4886# 0.26263f
C583 a_21585_12135# uo_out<0> 0.05052f
C584 a_6059_5710# a_6491_5710# 0.21349f
C585 a_18932_7762# a_18932_7282# 0.02114f
C586 LELO_GR02_0.OSCILLATOR_0.PWRUP_B_1V8 a_12542_9428# 0.01436f
C587 LELO_GR02_0.OSCILLATOR_0.PWRUP_N_1V8 LELO_GR02_0.OSCILLATOR_0.x13<2>.B 0.1263f
C588 LELO_GR02_0.BANDGAP_0.x2.x2<1>.A a_7268_10332# 0.09281f
C589 LELO_GR02_0.BANDGAP_0.x2.LELOATR_PCH_12C5F0_7.G a_5141_9860# 0.0386f
C590 a_9590_12422# a_9590_12262# 0.0971f
C591 a_5506_11266# VDPWR 0.67191f
C592 LELO_GR02_0.OSCILLATOR_0.x6.CK a_20984_6827# 0.01307f
C593 LELO_GR02_0.OSCILLATOR_0.x5.x7.G a_17682_8056# 0.10571f
C594 uio_oe<5> uio_oe<4> 0.0456f
C595 a_8748_15598# LELO_GR02_0.BANDGAP_0.x5.A 0.01045f
C596 LELO_GR02_0.OSCILLATOR_0.x5.x11.S a_18932_14700# 0.06235f
C597 LELO_GR02_0.OSCILLATOR_0.PWRUP_N_1V8 LELO_GR02_0.BANDGAP_0.x5.B 0.90892f
C598 a_18214_4886# a_18646_4886# 0.21349f
C599 a_11030_9428# LELO_GR02_0.BANDGAP_0.x8.DN 0.30139f
C600 LELO_GR02_0.OSCILLATOR_0.x6.D VDPWR 2.67074f
C601 a_20745_12135# uo_out<0> 0.01858f
C602 LELO_GR02_0.OSCILLATOR_0.PWRUP_N_1V8 LELO_GR02_0.OSCILLATOR_0.x6.CK 1.32324f
C603 LELO_GR02_0.BANDGAP_0.x5.B a_7268_11132# 0.03927f
C604 a_7268_12066# VDPWR 0.6717f
C605 LELO_GR02_0.OSCILLATOR_0.x6.CK a_20984_6987# 0.04241f
C606 a_21585_9415# a_21585_9095# 0.01f
C607 LELO_GR02_0.OSCILLATOR_0.x5.x7.G a_18932_8856# 0.06944f
C608 LELO_GR02_0.OSCILLATOR_0.x5.x11.S LELO_GR02_0.OSCILLATOR_0.x5.x9<4>.D 1.19479f
C609 a_8748_15598# a_8748_15438# 0.15007f
C610 LELO_GR02_0.BANDGAP_0.x2.x2.P a_8748_14798# 0.02741f
C611 a_6392_9060# a_5773_8770# 0.01385f
C612 LELO_GR02_0.BANDGAP_0.x2.x2.P a_5773_8770# 0.01252f
C613 a_21585_12135# VDPWR 0.29288f
C614 a_5843_3790# a_6275_3790# 0.14233f
C615 a_3743_11266# VDPWR 0.6712f
C616 LELO_GR02_0.OSCILLATOR_0.x6.CK a_20984_7467# 0.04719f
C617 LELO_GR02_0.OSCILLATOR_0.x5.x7.G a_17682_8856# 0.08512f
C618 uio_oe<6> uio_oe<5> 0.04933f
C619 LELO_GR02_0.OSCILLATOR_0.x5.x11.S a_17682_14700# 0.05869f
C620 a_17998_2966# a_18430_2966# 0.14233f
C621 a_20745_12135# VDPWR 0.02304f
C622 ui_in<2> ui_in<1> 0.03102f
C623 a_5506_12200# a_5506_12066# 0.23893f
C624 a_9590_12661# a_9590_12422# 0.05776f
C625 LELO_GR02_0.BANDGAP_0.x2.x2<1>.A a_5506_10332# 0.04504f
C626 a_5506_12066# VDPWR 0.67191f
C627 LELO_GR02_0.OSCILLATOR_0.x6.CK a_20984_7627# 0.03023f
C628 a_20745_9415# a_20745_9095# 0.01f
C629 LELO_GR02_0.BANDGAP_0.x2.x2.P LELO_GR02_0.BANDGAP_0.x5.A 0.0108f
C630 LELO_GR02_0.OSCILLATOR_0.x5.x11.S a_18932_15500# 0.06955f
C631 LELO_GR02_0.OSCILLATOR_0.PWRUP_N_1V8 LELO_GR02_0.BANDGAP_0.x2.x2<1>.A 0.78489f
C632 LELO_GR02_0.OSCILLATOR_0.x5.x7.G a_19078_4886# 0.26272f
C633 a_20567_12681# VDPWR 0.54311f
C634 LELO_GR02_0.BANDGAP_0.x2.x2<1>.A a_7268_11132# 0.07831f
C635 a_3743_12066# VDPWR 0.6712f
C636 LELO_GR02_0.OSCILLATOR_0.x6.CK a_18932_7006# 0.03768f
C637 uio_oe<7> uio_oe<6> 0.0484f
C638 LELO_GR02_0.OSCILLATOR_0.x5.x11.S LELO_GR02_0.OSCILLATOR_0.x5.x11.G 2.94839f
C639 LELO_GR02_0.BANDGAP_0.x2.x6.D a_7023_7969# 0.07646f
C640 LELO_GR02_0.OSCILLATOR_0.x5.x11.G LELO_GR02_0.OSCILLATOR_0.x5.x7.G 0.01034f
C641 LELO_GR02_0.OSCILLATOR_0.I_PTAT a_18932_10314# 0.07044f
C642 a_7642_9218# a_7642_9058# 0.15007f
C643 a_17426_7762# a_17426_7282# 0.02114f
C644 a_20567_13481# VDPWR 0.53622f
C645 ui_in<3> ui_in<2> 0.03102f
C646 LELO_GR02_0.BANDGAP_0.x5.B a_9590_11225# 0.08125f
C647 a_9590_12262# VDPWR 0.35583f
C648 LELO_GR02_0.OSCILLATOR_0.x6.CK a_18932_7122# 0.05068f
C649 a_5664_14970# a_5664_14810# 0.15007f
C650 LELO_GR02_0.OSCILLATOR_0.x5.x11.S a_17682_15500# 0.09084f
C651 LELO_GR02_0.BANDGAP_0.x2.x6.D a_5773_7970# 0.07647f
C652 a_5141_9060# a_4521_8769# 0.01373f
C653 a_21585_8295# a_20984_7627# 0.01249f
C654 a_3743_12200# a_3743_12066# 0.23893f
C655 a_9590_12821# a_9590_12661# 0.0971f
C656 LELO_GR02_0.BANDGAP_0.x5.B a_9590_11385# 0.01088f
C657 LELO_GR02_0.BANDGAP_0.x2.x2<1>.A a_5506_11132# 0.03256f
C658 LELO_GR02_0.BANDGAP_0.x2.LELOATR_PCH_12C5F0_7.G a_5506_10332# 0.07092f
C659 a_9590_12422# VDPWR 0.36937f
C660 LELO_GR02_0.OSCILLATOR_0.x6.CK a_18932_7282# 0.03827f
C661 LELO_GR02_0.OSCILLATOR_0.PWRUP_B_1V8 LELO_GR02_0.OSCILLATOR_0.x5.x9<4>.D 0.04969f
C662 LELO_GR02_0.BANDGAP_0.x2.x2.P a_5664_14810# 0.12211f
C663 LELO_GR02_0.OSCILLATOR_0.PWRUP_N_1V8 LELO_GR02_0.BANDGAP_0.x2.LELOATR_PCH_12C5F0_7.G 1.03199f
C664 LELO_GR02_0.BANDGAP_0.x2.LELOATR_NCH_4C5F0_5.D a_5773_7970# 0.0311f
C665 LELO_GR02_0.BANDGAP_0.x2.x6.D a_7023_8769# 0.07043f
C666 LELO_GR02_0.OSCILLATOR_0.I_PTAT a_18932_11114# 0.1428f
C667 ui_in<4> ui_in<3> 0.03102f
C668 LELO_GR02_0.OSCILLATOR_0.I_PTAT a_9590_12661# 0.02218f
C669 LELO_GR02_0.BANDGAP_0.x5.B a_7268_11266# 0.03896f
C670 a_7268_12200# VDPWR 0.67199f
C671 LELO_GR02_0.BANDGAP_0.x2.x2.P a_5664_14970# 0.05193f
C672 LELO_GR02_0.OSCILLATOR_0.x5.x11.S a_18646_4886# 0.03867f
C673 LELO_GR02_0.BANDGAP_0.x2.x6.D a_4521_7969# 0.1087f
C674 a_7642_9698# a_7642_9218# 0.02114f
C675 a_5627_5710# a_6059_5710# 0.21349f
C676 LELO_GR02_0.OSCILLATOR_0.x5.x7.G a_18646_4886# 0.26329f
C677 a_7268_13000# a_7268_12200# 0.01761f
C678 LELO_GR02_0.OSCILLATOR_0.I_PTAT a_9590_12821# 0.03769f
C679 LELO_GR02_0.BANDGAP_0.x5.B a_9590_11622# 0.01082f
C680 LELO_GR02_0.BANDGAP_0.x2.LELOATR_PCH_12C5F0_7.G a_3743_10332# 0.11528f
C681 a_9590_12661# VDPWR 0.36937f
C682 ui_in<0> uo_out<0> 0.40043f
C683 a_5664_15450# a_5664_14970# 0.02114f
C684 LELO_GR02_0.BANDGAP_0.x2.x6.D a_5773_8770# 0.07161f
C685 LELO_GR02_0.OSCILLATOR_0.x6.CK LELO_GR02_0.OSCILLATOR_0.x6.XA7.CN 0.0164f
C686 a_17782_4886# a_18214_4886# 0.21349f
C687 LELO_GR02_0.OSCILLATOR_0.I_PTAT a_18932_11914# 0.14288f
C688 ui_in<5> ui_in<4> 0.03102f
C689 LELO_GR02_0.BANDGAP_0.x5.B a_9590_11782# 0.08117f
C690 LELO_GR02_0.BANDGAP_0.x2.LELOATR_PCH_12C5F0_7.G a_5506_11132# 0.07582f
C691 LELO_GR02_0.OSCILLATOR_0.V_CTAT LELO_GR02_0.BANDGAP_0.x4.D 0.65763f
C692 a_9590_12821# VDPWR 0.35554f
C693 VDPWR uo_out<0> 6.63296f
C694 a_5664_15450# LELO_GR02_0.BANDGAP_0.x2.x2.P 0.0396f
C695 LELO_GR02_0.BANDGAP_0.x5.B a_7139_3790# 0.01682f
C696 LELO_GR02_0.BANDGAP_0.x2.LELOATR_NCH_4C5F0_5.D a_5773_8770# 0.04329f
C697 LELO_GR02_0.BANDGAP_0.x2.x6.D a_4521_8769# 0.11262f
C698 LELO_GR02_0.OSCILLATOR_0.x6.CK LELO_GR02_0.OSCILLATOR_0.x6.XA7.C 0.14793f
C699 LELO_GR02_0.BANDGAP_0.x4.D LELO_GR02_0.OSCILLATOR_0.x13<2>.B 0.01329f
C700 a_5411_3790# a_5843_3790# 0.14233f
C701 LELO_GR02_0.BANDGAP_0.x2.x2<1>.A a_7268_11266# 0.078f
C702 LELO_GR02_0.BANDGAP_0.x5.B LELO_GR02_0.BANDGAP_0.x4.D 0.94448f
C703 LELO_GR02_0.BANDGAP_0.x2.LELOATR_PCH_12C5F0_7.G a_3743_11132# 0.11352f
C704 LELO_GR02_0.OSCILLATOR_0.I_PTAT VDPWR 2.03331f
C705 VDPWR ui_in<0> 2.16727f
C706 a_5664_15610# LELO_GR02_0.BANDGAP_0.x2.x2.P 0.01142f
C707 a_17566_2966# a_17998_2966# 0.14233f
C708 a_7642_9858# a_7642_9698# 0.15007f
C709 LELO_GR02_0.OSCILLATOR_0.I_PTAT a_18932_12714# 0.147f
C710 ui_in<6> ui_in<5> 0.03102f
C711 a_5506_12200# VDPWR 0.67191f
C712 a_5664_15610# a_5664_15450# 0.15007f
C713 LELO_GR02_0.OSCILLATOR_0.x5.x9<4>.S a_18932_10314# 0.06635f
C714 LELO_GR02_0.BANDGAP_0.x5.B a_6707_3790# 0.01139f
C715 LELO_GR02_0.OSCILLATOR_0.x5.x11.S a_18214_4886# 0.04412f
C716 LELO_GR02_0.OSCILLATOR_0.I_PTAT a_17682_12715# 0.01654f
C717 LELO_GR02_0.OSCILLATOR_0.x5.x7.G a_18214_4886# 0.27303f
C718 LELO_GR02_0.BANDGAP_0.x5.B a_7268_12066# 0.03673f
C719 a_7268_13000# VDPWR 0.67453f
C720 LELO_GR02_0.OSCILLATOR_0.x6.CK LELO_GR02_0.OSCILLATOR_0.x6.D 0.03708f
C721 LELO_GR02_0.OSCILLATOR_0.x5.x9<4>.S a_17682_10315# 0.07111f
C722 LELO_GR02_0.BANDGAP_0.x2.x2<1>.A a_7139_3790# 0.04065f
C723 LELO_GR02_0.OSCILLATOR_0.I_PTAT a_18932_13514# 0.14279f
C724 LELO_GR02_0.BANDGAP_0.x4.D a_12974_9428# 0.02611f
C725 ui_in<7> ui_in<6> 0.03102f
C726 LELO_GR02_0.BANDGAP_0.x2.x2<1>.A LELO_GR02_0.BANDGAP_0.x4.D 2.09873f
C727 a_3743_12200# VDPWR 0.6712f
C728 LELO_GR02_0.OSCILLATOR_0.x5.x9<4>.S a_18932_11114# 0.12007f
C729 LELO_GR02_0.OSCILLATOR_0.PWRUP_B_1V8 a_21585_9095# 0.05912f
C730 a_5506_13000# a_5506_12200# 0.01761f
C731 LELO_GR02_0.BANDGAP_0.x2.x2<1>.A a_5506_11266# 0.03228f
C732 LELO_GR02_0.OSCILLATOR_0.PWRUP_B_1V8 LELO_GR02_0.BANDGAP_0.x8.DN 0.42653f
C733 a_5506_13000# VDPWR 0.67474f
C734 LELO_GR02_0.OSCILLATOR_0.PWRUP_N_1V8 LELO_GR02_0.OSCILLATOR_0.x5.x11.G 0.64323f
C735 LELO_GR02_0.OSCILLATOR_0.x5.x9<4>.S a_17682_11115# 0.12267f
C736 LELO_GR02_0.BANDGAP_0.x2.x2<1>.A a_6707_3790# 0.0123f
C737 LELO_GR02_0.OSCILLATOR_0.PWRUP_B_1V8 a_20745_9095# 0.06788f
C738 LELO_GR02_0.OSCILLATOR_0.I_PTAT a_18932_14314# 0.07043f
C739 uio_in<0> ui_in<7> 0.03102f
C740 a_9590_13301# LELO_GR02_0.OSCILLATOR_0.I_PTAT 0.02902f
C741 LELO_GR02_0.BANDGAP_0.x2.x2<1>.A a_7268_12066# 0.07582f
C742 LELO_GR02_0.BANDGAP_0.x2.x2.P LELO_GR02_0.BANDGAP_0.x2.x6.D 0.54889f
C743 a_3743_13000# VDPWR 0.67397f
C744 a_18185_16361# a_18185_16201# 0.15007f
C745 LELO_GR02_0.OSCILLATOR_0.x6.CK a_20567_12681# 0.03784f
C746 LELO_GR02_0.OSCILLATOR_0.x5.x9<4>.S a_18932_11914# 0.12062f
C747 LELO_GR02_0.OSCILLATOR_0.x5.x11.S a_17782_4886# 0.11845f
C748 LELO_GR02_0.BANDGAP_0.x2.LELOATR_NCH_4C5F0_5.D a_6392_9060# 0.05458f
C749 LELO_GR02_0.OSCILLATOR_0.I_PTAT LELO_GR02_0.OSCILLATOR_0.x5.x9<4>.S 4.5766f
C750 a_18932_14314# VDPWR 0.04501f
C751 a_5195_3790# a_5411_3790# 0.01515f
C752 LELO_GR02_0.OSCILLATOR_0.x5.x7.G a_17782_4886# 0.01814f
C753 a_9590_13461# LELO_GR02_0.OSCILLATOR_0.I_PTAT 0.01077f
C754 LELO_GR02_0.BANDGAP_0.x2.LELOATR_PCH_12C5F0_7.G LELO_GR02_0.BANDGAP_0.x4.D 0.30988f
C755 LELO_GR02_0.BANDGAP_0.x5.B a_9590_12262# 0.08122f
C756 LELO_GR02_0.BANDGAP_0.x5.A a_9590_10585# 0.04215f
C757 LELO_GR02_0.BANDGAP_0.x2.x2.P LELO_GR02_0.BANDGAP_0.x2.LELOATR_NCH_4C5F0_5.D 0.80444f
C758 a_9590_13301# VDPWR 0.3559f
C759 LELO_GR02_0.OSCILLATOR_0.x6.XA7.C LELO_GR02_0.OSCILLATOR_0.x6.XA1.MN1.S 0.07714f
C760 LELO_GR02_0.OSCILLATOR_0.x5.x11.S a_18185_16201# 0.02838f
C761 LELO_GR02_0.OSCILLATOR_0.PWRUP_N_1V8 a_8748_14798# 0.01616f
C762 LELO_GR02_0.OSCILLATOR_0.x6.CK a_20567_13481# 0.01422f
C763 LELO_GR02_0.OSCILLATOR_0.x5.x9<4>.S a_17682_11915# 0.1269f
C764 a_17350_4886# a_17782_4886# 0.21349f
C765 LELO_GR02_0.OSCILLATOR_0.V_CTAT a_17682_10315# 0.0876f
C766 LELO_GR02_0.OSCILLATOR_0.x5.x9<4>.S VDPWR 0.05864f
C767 uio_in<1> uio_in<0> 0.03102f
C768 a_3743_13000# a_3743_12200# 0.01761f
C769 LELO_GR02_0.BANDGAP_0.x5.B a_9590_12422# 0.01312f
C770 LELO_GR02_0.BANDGAP_0.x2.x2<1>.A a_5506_12066# 0.02985f
C771 LELO_GR02_0.BANDGAP_0.x2.LELOATR_PCH_12C5F0_7.G a_5506_11266# 0.07582f
C772 LELO_GR02_0.BANDGAP_0.x5.A a_9590_10745# 0.05756f
C773 a_9590_13461# VDPWR 0.37275f
C774 LELO_GR02_0.OSCILLATOR_0.x5.x11.S a_18185_16361# 0.05179f
C775 LELO_GR02_0.OSCILLATOR_0.PWRUP_N_1V8 a_8748_14958# 0.08256f
C776 LELO_GR02_0.OSCILLATOR_0.x5.x9<4>.S a_18932_12714# 0.12009f
C777 LELO_GR02_0.OSCILLATOR_0.x5.x11.S a_18323_9235# 0.01065f
C778 LELO_GR02_0.BANDGAP_0.x4.D a_12326_11348# 0.33641f
C779 a_17682_14315# VDPWR 0.045f
C780 LELO_GR02_0.BANDGAP_0.x5.B a_7268_12200# 0.03634f
C781 a_7269_13136# VDPWR 0.67449f
C782 LELO_GR02_0.OSCILLATOR_0.x5.x7.G a_18323_9235# 0.08427f
C783 a_18185_16841# a_18185_16361# 0.02114f
C784 LELO_GR02_0.OSCILLATOR_0.PWRUP_N_1V8 LELO_GR02_0.BANDGAP_0.x5.A 0.22671f
C785 LELO_GR02_0.OSCILLATOR_0.x5.x9<4>.S a_17682_12715# 0.12094f
C786 a_17134_2966# a_17566_2966# 0.14233f
C787 a_3635_9219# a_3635_9059# 0.15007f
C788 LELO_GR02_0.BANDGAP_0.x2.LELOATR_NCH_4C5F0_5.D a_5141_9060# 0.05306f
C789 LELO_GR02_0.OSCILLATOR_0.x5.x11.S LELO_GR02_0.OSCILLATOR_0.x5.x7.G 1.27943f
C790 LELO_GR02_0.OSCILLATOR_0.V_CTAT a_17682_11115# 0.14277f
C791 LELO_GR02_0.OSCILLATOR_0.I_PTAT a_15861_10586# 0.02509f
C792 uio_in<2> uio_in<1> 0.03102f
C793 a_7269_13136# a_7268_13000# 0.23356f
C794 LELO_GR02_0.BANDGAP_0.x5.B a_9590_12661# 0.01276f
C795 LELO_GR02_0.BANDGAP_0.x2.LELOATR_PCH_12C5F0_7.G a_3743_11266# 0.11344f
C796 a_9590_13714# VDPWR 0.37281f
C797 a_18185_16841# LELO_GR02_0.OSCILLATOR_0.x5.x11.S 0.06101f
C798 LELO_GR02_0.OSCILLATOR_0.PWRUP_N_1V8 a_8748_15438# 0.08184f
C799 LELO_GR02_0.OSCILLATOR_0.x5.x11.S a_17350_4886# 0.47691f
C800 LELO_GR02_0.OSCILLATOR_0.x5.x9<4>.S a_18932_13514# 0.12008f
C801 LELO_GR02_0.BANDGAP_0.x2.x6.D a_3635_9059# 0.01881f
C802 LELO_GR02_0.BANDGAP_0.x2.LELOATR_NCH_4C5F0_5.D a_6392_9860# 0.05643f
C803 LELO_GR02_0.OSCILLATOR_0.I_PTAT a_16245_11265# 0.0576f
C804 LELO_GR02_0.BANDGAP_0.x5.B a_9590_12821# 0.08162f
C805 LELO_GR02_0.BANDGAP_0.x2.LELOATR_PCH_12C5F0_7.G a_5506_12066# 0.07582f
C806 LELO_GR02_0.OSCILLATOR_0.V_CTAT LELO_GR02_0.OSCILLATOR_0.I_PTAT 3.47396f
C807 LELO_GR02_0.BANDGAP_0.x2.x2.P a_7268_10332# 0.11128f
C808 LELO_GR02_0.OSCILLATOR_0.x6.XA5.A LELO_GR02_0.OSCILLATOR_0.x6.XA3.MP1.S 0.04373f
C809 a_9590_13874# VDPWR 0.35582f
C810 a_18323_10035# LELO_GR02_0.OSCILLATOR_0.x5.x7.G 0.07044f
C811 a_18185_17001# LELO_GR02_0.OSCILLATOR_0.x5.x11.S 0.12452f
C812 LELO_GR02_0.OSCILLATOR_0.x5.x9<4>.S a_17682_13515# 0.12281f
C813 LELO_GR02_0.BANDGAP_0.x2.x6.D a_3635_9219# 0.0403f
C814 LELO_GR02_0.OSCILLATOR_0.V_CTAT a_17682_11915# 0.14277f
C815 LELO_GR02_0.OSCILLATOR_0.I_PTAT LELO_GR02_0.OSCILLATOR_0.x13<2>.B 32.875f
C816 LELO_GR02_0.OSCILLATOR_0.x6.CK uo_out<0> 0.05969f
C817 uio_in<3> uio_in<2> 0.03102f
C818 LELO_GR02_0.BANDGAP_0.x2.x2<1>.A a_7268_12200# 0.07582f
C819 LELO_GR02_0.BANDGAP_0.x5.B LELO_GR02_0.OSCILLATOR_0.I_PTAT 0.45747f
C820 LELO_GR02_0.BANDGAP_0.x2.LELOATR_PCH_12C5F0_7.G a_3743_12066# 0.11317f
C821 LELO_GR02_0.OSCILLATOR_0.x6.XA5.A LELO_GR02_0.OSCILLATOR_0.x6.XA3.MN1.S 0.04373f
C822 LELO_GR02_0.OSCILLATOR_0.V_CTAT VDPWR 1.47183f
C823 a_18185_17001# a_18185_16841# 0.15007f
C824 LELO_GR02_0.OSCILLATOR_0.PWRUP_N_1V8 a_5664_14810# 0.03105f
C825 LELO_GR02_0.OSCILLATOR_0.x5.x9<4>.S a_18932_14314# 0.0583f
C826 LELO_GR02_0.BANDGAP_0.x4.D a_11894_11348# 0.10945f
C827 LELO_GR02_0.OSCILLATOR_0.I_PTAT LELO_GR02_0.OSCILLATOR_0.x6.CK 1.85684f
C828 a_7268_10332# a_7642_9858# 0.02737f
C829 LELO_GR02_0.OSCILLATOR_0.x13<2>.B VDPWR 0.07075f
C830 a_9590_13461# a_9590_13301# 0.0971f
C831 LELO_GR02_0.OSCILLATOR_0.PWRUP_N_1V8 a_7642_9218# 0.08074f
C832 LELO_GR02_0.OSCILLATOR_0.x6.XA5.A a_21585_9895# 0.02049f
C833 LELO_GR02_0.BANDGAP_0.x5.B VDPWR 5.8592f
C834 LELO_GR02_0.OSCILLATOR_0.PWRUP_N_1V8 a_5664_14970# 0.09353f
C835 LELO_GR02_0.OSCILLATOR_0.x5.x11.S a_16918_2966# 0.01759f
C836 LELO_GR02_0.OSCILLATOR_0.V_CTAT a_17682_12715# 0.14277f
C837 LELO_GR02_0.OSCILLATOR_0.I_PTAT a_16245_12065# 0.07836f
C838 LELO_GR02_0.BANDGAP_0.x2.LELOATR_NCH_4C5F0_5.D LELO_GR02_0.BANDGAP_0.x2.x6.D 0.85724f
C839 LELO_GR02_0.OSCILLATOR_0.x6.CK VDPWR 1.22169f
C840 a_18932_7922# a_18932_7762# 0.15007f
C841 uio_in<4> uio_in<3> 0.03102f
C842 LELO_GR02_0.BANDGAP_0.x5.B a_7268_13000# 0.03672f
C843 LELO_GR02_0.BANDGAP_0.x5.A a_9590_11225# 0.06019f
C844 LELO_GR02_0.BANDGAP_0.x2.x2.P a_5506_10332# 0.14541f
C845 LELO_GR02_0.OSCILLATOR_0.x6.XA5.A a_20745_9895# 0.02736f
C846 a_5507_13136# VDPWR 0.6747f
C847 LELO_GR02_0.OSCILLATOR_0.PWRUP_B_1V8 LELO_GR02_0.OSCILLATOR_0.x5.x11.S 0.15572f
C848 LELO_GR02_0.OSCILLATOR_0.PWRUP_N_1V8 LELO_GR02_0.BANDGAP_0.x2.x2.P 2.64007f
C849 LELO_GR02_0.BANDGAP_0.x5.B a_5411_3790# 0.01134f
C850 a_17682_14315# LELO_GR02_0.OSCILLATOR_0.x5.x9<4>.S 0.06612f
C851 a_3635_9699# a_3635_9219# 0.02114f
C852 LELO_GR02_0.OSCILLATOR_0.PWRUP_B_1V8 LELO_GR02_0.OSCILLATOR_0.x5.x7.G 0.18759f
C853 LELO_GR02_0.BANDGAP_0.x5.A a_9590_11385# 0.04933f
C854 LELO_GR02_0.BANDGAP_0.x2.x2.P a_7268_11132# 0.14876f
C855 LELO_GR02_0.OSCILLATOR_0.PWRUP_N_1V8 a_7642_9698# 0.08096f
C856 LELO_GR02_0.OSCILLATOR_0.x6.XA5.A LELO_GR02_0.OSCILLATOR_0.x6.XA4.MP1.S 0.05173f
C857 a_7269_13936# VDPWR 0.86266f
C858 a_15861_9946# a_15861_9786# 0.15007f
C859 LELO_GR02_0.OSCILLATOR_0.PWRUP_N_1V8 a_5664_15450# 0.08415f
C860 a_16918_2966# a_17134_2966# 0.01515f
C861 LELO_GR02_0.OSCILLATOR_0.V_CTAT a_17682_13515# 0.14277f
C862 a_3635_9699# LELO_GR02_0.BANDGAP_0.x2.x6.D 0.03854f
C863 a_5141_9860# LELO_GR02_0.BANDGAP_0.x2.LELOATR_NCH_4C5F0_5.D 0.05659f
C864 uio_in<5> uio_in<4> 0.03102f
C865 ena VGND 0.06659f
C866 clk VGND 0.04284f
C867 rst_n VGND 0.04185f
C868 ui_in<1> VGND 0.04152f
C869 ui_in<2> VGND 0.04228f
C870 ui_in<3> VGND 0.0423f
C871 ui_in<4> VGND 0.0423f
C872 ui_in<5> VGND 0.0423f
C873 ui_in<6> VGND 0.0423f
C874 ui_in<7> VGND 0.0423f
C875 uio_in<0> VGND 0.0423f
C876 uio_in<1> VGND 0.0423f
C877 uio_in<2> VGND 0.0423f
C878 uio_in<3> VGND 0.0423f
C879 uio_in<4> VGND 0.0423f
C880 uio_in<5> VGND 0.0423f
C881 uio_in<6> VGND 0.0423f
C882 uio_in<7> VGND 0.0423f
C883 uo_out<1> VGND 0.04181f
C884 uo_out<2> VGND 0.04198f
C885 uo_out<3> VGND 0.04198f
C886 uo_out<4> VGND 0.03352f
C887 uo_out<5> VGND 0.0423f
C888 uo_out<6> VGND 0.0423f
C889 uo_out<7> VGND 0.0423f
C890 uio_out<0> VGND 0.0423f
C891 uio_out<1> VGND 0.0423f
C892 uio_out<2> VGND 0.0423f
C893 uio_out<3> VGND 0.0423f
C894 uio_out<4> VGND 0.0423f
C895 uio_out<5> VGND 0.0423f
C896 uio_out<6> VGND 0.0423f
C897 uio_out<7> VGND 0.0423f
C898 uio_oe<0> VGND 0.05316f
C899 uio_oe<1> VGND 0.04356f
C900 uio_oe<2> VGND 0.04418f
C901 uio_oe<3> VGND 0.04293f
C902 uio_oe<4> VGND 0.04168f
C903 uio_oe<5> VGND 0.04418f
C904 uio_oe<6> VGND 0.04418f
C905 uio_oe<7> VGND 0.08647f
C906 uo_out<0> VGND 7.83174f
C907 ui_in<0> VGND 7.696f
C908 VDPWR VGND 0.31009p
C909 m4_9998_21956# VGND 0.01451f $ **FLOATING
C910 m4_6134_21932# VGND 0.01451f $ **FLOATING
C911 m1_5524_9447# VGND 0.01479f $ **FLOATING
C912 a_20590_2966# VGND 1.93767f $ **FLOATING
C913 a_20158_2966# VGND 0.52984f
C914 a_19942_4886# VGND 0.63171f
C915 a_19726_2966# VGND 0.43595f
C916 a_19510_4886# VGND 0.63171f
C917 a_19294_2966# VGND 0.43595f
C918 a_19078_4886# VGND 0.63245f
C919 a_18862_2966# VGND 0.43595f
C920 a_18646_4886# VGND 0.63171f
C921 a_18430_2966# VGND 0.43595f
C922 a_18214_4886# VGND 0.63171f
C923 a_17998_2966# VGND 0.43595f
C924 a_17782_4886# VGND 0.63171f
C925 a_17566_2966# VGND 0.43595f
C926 a_17350_4886# VGND 0.63348f
C927 a_17134_2966# VGND 0.52984f
C928 a_16918_2966# VGND 1.89352f $ **FLOATING
C929 a_18932_6366# VGND 0.85789f $ **FLOATING
C930 a_18932_6526# VGND 0.67811f $ **FLOATING
C931 a_17426_6366# VGND 0.85695f $ **FLOATING
C932 a_17426_6526# VGND 0.67788f $ **FLOATING
C933 a_20984_6827# VGND 0.86456f $ **FLOATING
C934 a_20984_6987# VGND 0.67808f $ **FLOATING
C935 a_20984_7467# VGND 0.6707f $ **FLOATING
C936 a_20984_7627# VGND 0.74481f $ **FLOATING
C937 a_18932_7006# VGND 0.61724f $ **FLOATING
C938 a_18932_7122# VGND 0.68219f $ **FLOATING
C939 a_18932_7282# VGND 0.61636f $ **FLOATING
C940 a_17426_7006# VGND 0.61738f $ **FLOATING
C941 a_17426_7122# VGND 0.68411f $ **FLOATING
C942 a_17426_7282# VGND 0.6175f $ **FLOATING
C943 a_7139_3790# VGND 1.96444f $ **FLOATING
C944 a_6707_3790# VGND 0.53896f
C945 a_6491_5710# VGND 0.6444f
C946 a_6275_3790# VGND 0.46183f
C947 a_6059_5710# VGND 0.91196f
C948 a_5843_3790# VGND 0.83083f
C949 a_5627_5710# VGND 0.87873f
C950 a_5411_3790# VGND 0.55557f
C951 a_5195_3790# VGND 1.96546f $ **FLOATING
C952 a_7023_7034# VGND 0.65189f $ **FLOATING
C953 a_18932_7762# VGND 0.66336f $ **FLOATING
C954 a_18932_7922# VGND 0.59671f $ **FLOATING
C955 a_17426_7762# VGND 0.66498f $ **FLOATING
C956 a_17426_7922# VGND 0.57543f $ **FLOATING
C957 a_5773_7035# VGND 0.6617f $ **FLOATING
C958 a_7023_7834# VGND 0.4968f $ **FLOATING
C959 a_4521_7034# VGND 0.64764f $ **FLOATING
C960 a_5773_7835# VGND 0.49532f $ **FLOATING
C961 a_4521_7834# VGND 0.49508f $ **FLOATING
C962 a_21585_8295# VGND 0.09696f $ **FLOATING
C963 a_20745_8295# VGND 0.47145f $ **FLOATING
C964 a_20745_8615# VGND 0.4038f $ **FLOATING
C965 LELO_GR02_0.OSCILLATOR_0.x6.XA1.MN1.S VGND 0.0969f
C966 a_18932_8056# VGND 0.47946f $ **FLOATING
C967 a_17682_8056# VGND 0.47635f $ **FLOATING
C968 a_18932_8856# VGND 0.72875f $ **FLOATING
C969 a_17682_8856# VGND 0.72391f $ **FLOATING
C970 a_7023_7969# VGND 0.49679f $ **FLOATING
C971 a_5773_7970# VGND 0.4953f $ **FLOATING
C972 a_7023_8769# VGND 0.64339f $ **FLOATING
C973 a_4521_7969# VGND 0.49506f $ **FLOATING
C974 a_5773_8770# VGND 0.64105f $ **FLOATING
C975 a_4521_8769# VGND 0.64758f $ **FLOATING
C976 a_20745_9095# VGND 0.3123f $ **FLOATING
C977 a_20745_9415# VGND 0.31468f $ **FLOATING
C978 LELO_GR02_0.OSCILLATOR_0.x6.XA3.MN1.S VGND 0.09448f
C979 a_20745_9895# VGND 0.31632f $ **FLOATING
C980 a_18323_9235# VGND 0.68074f $ **FLOATING
C981 LELO_GR02_0.OSCILLATOR_0.x5.x7.G VGND 12.8543f
C982 a_18323_10035# VGND 0.69179f $ **FLOATING
C983 a_15861_9786# VGND 0.82513f $ **FLOATING
C984 a_15861_9946# VGND 0.67455f $ **FLOATING
C985 LELO_GR02_0.OSCILLATOR_0.x6.XA4.MN1.S VGND 0.08682f
C986 a_20745_10375# VGND 0.31123f $ **FLOATING
C987 LELO_GR02_0.OSCILLATOR_0.x6.XA5.A VGND 0.99883f
C988 a_20745_10695# VGND 0.31386f $ **FLOATING
C989 LELO_GR02_0.OSCILLATOR_0.x6.XA6.A VGND 0.97625f
C990 LELO_GR02_0.OSCILLATOR_0.x6.XA6.MN1.S VGND 0.08222f
C991 a_20745_11175# VGND 0.31656f $ **FLOATING
C992 LELO_GR02_0.OSCILLATOR_0.x6.XA7.MN2.D VGND 0.0979f
C993 LELO_GR02_0.OSCILLATOR_0.x6.XA7.MP2.S VGND 0.12129f
C994 LELO_GR02_0.OSCILLATOR_0.x6.XA7.CN VGND 1.44236f
C995 LELO_GR02_0.OSCILLATOR_0.x6.XA7.C VGND 2.59743f
C996 a_20745_11815# VGND 0.31278f $ **FLOATING
C997 LELO_GR02_0.OSCILLATOR_0.x6.D VGND 1.80989f
C998 a_21585_12135# VGND 0.07623f $ **FLOATING
C999 a_20745_12135# VGND 0.32242f $ **FLOATING
C1000 a_20567_12681# VGND 0.09062f $ **FLOATING
C1001 a_20567_13481# VGND 0.1113f $ **FLOATING
C1002 a_18932_10314# VGND 0.6341f $ **FLOATING
C1003 a_17682_10315# VGND 0.64184f $ **FLOATING
C1004 a_18932_11114# VGND 0.46943f $ **FLOATING
C1005 a_17682_11115# VGND 0.4694f $ **FLOATING
C1006 a_18932_11914# VGND 0.46939f $ **FLOATING
C1007 a_17682_11915# VGND 0.46862f $ **FLOATING
C1008 a_18932_12714# VGND 0.46779f $ **FLOATING
C1009 a_17682_12715# VGND 0.46888f $ **FLOATING
C1010 a_18932_13514# VGND 0.46779f $ **FLOATING
C1011 a_17682_13515# VGND 0.46888f $ **FLOATING
C1012 a_18932_14314# VGND 0.46521f $ **FLOATING
C1013 LELO_GR02_0.OSCILLATOR_0.x5.x9<4>.S VGND 4.03816f
C1014 a_17682_14315# VGND 0.46486f $ **FLOATING
C1015 a_15861_10426# VGND 0.65965f $ **FLOATING
C1016 a_15861_10586# VGND 0.64474f $ **FLOATING
C1017 a_16245_11265# VGND 0.43301f $ **FLOATING
C1018 LELO_GR02_0.OSCILLATOR_0.x13<2>.B VGND 10.0073f
C1019 LELO_GR02_0.OSCILLATOR_0.x6.CK VGND 10.818f
C1020 a_16245_12065# VGND 0.51338f $ **FLOATING
C1021 a_12974_9428# VGND 1.91723f $ **FLOATING
C1022 a_12542_9428# VGND 0.52959f
C1023 a_12326_11348# VGND 0.63171f
C1024 a_12110_9428# VGND 0.43595f
C1025 a_11894_11348# VGND 0.63171f
C1026 a_11678_9428# VGND 0.43595f
C1027 a_11462_11348# VGND 0.63171f
C1028 a_11246_9428# VGND 0.52984f
C1029 LELO_GR02_0.BANDGAP_0.x8.DN VGND 16.6401f
C1030 a_11030_9428# VGND 1.85094f $ **FLOATING
C1031 a_7642_9058# VGND 0.84058f $ **FLOATING
C1032 a_7642_9218# VGND 0.68243f $ **FLOATING
C1033 a_6392_9060# VGND 0.65614f $ **FLOATING
C1034 a_7642_9698# VGND 0.6578f $ **FLOATING
C1035 a_7642_9858# VGND 0.60803f $ **FLOATING
C1036 a_5141_9060# VGND 0.65516f $ **FLOATING
C1037 a_6392_9860# VGND 0.49484f $ **FLOATING
C1038 a_3635_9059# VGND 0.85427f $ **FLOATING
C1039 a_3635_9219# VGND 0.68159f $ **FLOATING
C1040 LELO_GR02_0.BANDGAP_0.x2.x6.D VGND 21.8057f
C1041 LELO_GR02_0.BANDGAP_0.x2.LELOATR_NCH_4C5F0_5.D VGND 2.93206f
C1042 a_5141_9860# VGND 0.49307f $ **FLOATING
C1043 a_3635_9699# VGND 0.65891f $ **FLOATING
C1044 a_3635_9859# VGND 0.60625f $ **FLOATING
C1045 a_7268_10332# VGND 0.14613f $ **FLOATING
C1046 a_9590_10585# VGND 0.09222f $ **FLOATING
C1047 a_5506_10332# VGND 0.14028f $ **FLOATING
C1048 a_3743_10332# VGND 0.14019f $ **FLOATING
C1049 LELO_GR02_0.BANDGAP_0.x4.D VGND 3.71695f
C1050 LELO_GR02_0.OSCILLATOR_0.I_PTAT VGND 25.4629f
C1051 LELO_GR02_0.OSCILLATOR_0.V_CTAT VGND 20.4813f
C1052 LELO_GR02_0.BANDGAP_0.x5.B VGND 13.402f
C1053 a_7269_13936# VGND 0.17022f $ **FLOATING
C1054 LELO_GR02_0.BANDGAP_0.x2.x2<1>.A VGND 16.0294f
C1055 a_5507_13936# VGND 0.15513f $ **FLOATING
C1056 LELO_GR02_0.BANDGAP_0.x2.LELOATR_PCH_12C5F0_7.G VGND 3.08162f
C1057 a_3744_13936# VGND 0.17389f $ **FLOATING
C1058 a_9590_14514# VGND 0.02677f $ **FLOATING
C1059 a_18932_14700# VGND 0.03452f $ **FLOATING
C1060 LELO_GR02_0.OSCILLATOR_0.x5.x9<4>.D VGND 1.48323f
C1061 a_17682_14700# VGND 0.03446f $ **FLOATING
C1062 a_18932_15500# VGND 0.05847f $ **FLOATING
C1063 LELO_GR02_0.OSCILLATOR_0.x5.x11.G VGND 1.44278f
C1064 a_17682_15500# VGND 0.05534f $ **FLOATING
C1065 a_8748_14798# VGND 0.05671f $ **FLOATING
C1066 LELO_GR02_0.BANDGAP_0.x5.A VGND 0.7345f
C1067 a_8748_15598# VGND 0.14323f $ **FLOATING
C1068 a_5664_14810# VGND 0.11845f $ **FLOATING
C1069 LELO_GR02_0.BANDGAP_0.x2.x2.P VGND 7.01825f
C1070 a_5664_15610# VGND 0.14323f $ **FLOATING
C1071 a_18185_16201# VGND 0.11015f $ **FLOATING
C1072 LELO_GR02_0.OSCILLATOR_0.x5.x11.S VGND 9.19675f
C1073 a_18185_17001# VGND 0.14323f $ **FLOATING
C1074 a_8598_17876# VGND 0.08125f $ **FLOATING
C1075 a_7758_17876# VGND 0.36086f $ **FLOATING
C1076 LELO_GR02_0.OSCILLATOR_0.PWRUP_B_1V8 VGND 22.9038f
C1077 a_8598_18196# VGND 0.05561f $ **FLOATING
C1078 a_7758_18196# VGND 0.33645f $ **FLOATING
C1079 a_8598_18706# VGND 0.05817f $ **FLOATING
C1080 a_7758_18706# VGND 0.41672f $ **FLOATING
C1081 LELO_GR02_0.OSCILLATOR_0.PWRUP_N_1V8 VGND 23.1228f
C1082 a_8598_19026# VGND 0.08883f $ **FLOATING
C1083 a_7758_19026# VGND 0.35929f $ **FLOATING
C1084 a_28996_20830# VGND 0.09847f $ **FLOATING
C1085 a_28156_20830# VGND 0.445f $ **FLOATING
C1086 a_28156_21150# VGND 0.39995f $ **FLOATING
C1087 JNWTR_TIEL_CV_0.MP0.G VGND 0.53358f
C1088 JNWTR_TIEL_CV_0.Y VGND 7.62019f
C1089 a_28996_21470# VGND 0.08187f $ **FLOATING
C1090 a_28156_21470# VGND 0.3474f $ **FLOATING
.ends
