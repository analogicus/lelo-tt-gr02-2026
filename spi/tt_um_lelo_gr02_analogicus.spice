** sch_path: /Users/wulff/data/2023/aicex/ip/lelo_gr02_sky130a/design/LELO_GR02_SKY130A/tt_um_lelo_gr02_analogicus.sch
.subckt tt_um_lelo_gr02_analogicus uo_out<7> uo_out<6> uo_out<5> uo_out<4> uo_out<3> uo_out<2> uo_out<1> uo_out<0>
+ uio_out<7> uio_out<6> uio_out<5> uio_out<4> uio_out<3> uio_out<2> uio_out<1> uio_out<0> uio_oe<7> uio_oe<6> uio_oe<5> uio_oe<4> uio_oe<3> uio_oe<2> uio_oe<1> uio_oe<0> VDPWR VGND
+ ui_in<7> ui_in<6> ui_in<5> ui_in<4> ui_in<3> ui_in<2> ui_in<1> ui_in<0> uio_in<7> uio_in<6> uio_in<5> uio_in<4> uio_in<3> uio_in<2> uio_in<1> uio_in<0> ena rst_n clk
*.opin uo_out<7> uo_out<6> uo_out<5> uo_out<4> uo_out<3> uo_out<2> uo_out<1> uo_out<0>
*.opin uio_out<7> uio_out<6> uio_out<5> uio_out<4> uio_out<3> uio_out<2> uio_out<1> uio_out<0>
*.opin uio_oe<7> uio_oe<6> uio_oe<5> uio_oe<4> uio_oe<3> uio_oe<2> uio_oe<1> uio_oe<0>
*.ipin VDPWR
*.ipin VGND
*.ipin ui_in<7> ui_in<6> ui_in<5> ui_in<4> ui_in<3> ui_in<2> ui_in<1> ui_in<0>
*.ipin uio_in<7> uio_in<6> uio_in<5> uio_in<4> uio_in<3> uio_in<2> uio_in<1> uio_in<0>
*.ipin ena
*.ipin rst_n
*.ipin clk
x8 VDPWR VGND JNWTR_TAPCELLB_CV
x9 TIE_L VDPWR VGND JNWTR_TIEL_CV
R1<7> TIE_L uio_oe<7> sky130_fd_pr__res_generic_m4 W=0.3 L=0.3 m=1
R1<6> TIE_L uio_oe<6> sky130_fd_pr__res_generic_m4 W=0.3 L=0.3 m=1
R1<5> TIE_L uio_oe<5> sky130_fd_pr__res_generic_m4 W=0.3 L=0.3 m=1
R1<4> TIE_L uio_oe<4> sky130_fd_pr__res_generic_m4 W=0.3 L=0.3 m=1
R1<3> TIE_L uio_oe<3> sky130_fd_pr__res_generic_m4 W=0.3 L=0.3 m=1
R1<2> TIE_L uio_oe<2> sky130_fd_pr__res_generic_m4 W=0.3 L=0.3 m=1
R1<1> TIE_L uio_oe<1> sky130_fd_pr__res_generic_m4 W=0.3 L=0.3 m=1
R1<0> TIE_L uio_oe<0> sky130_fd_pr__res_generic_m4 W=0.3 L=0.3 m=1
x1 VDPWR uo_out<0> ui_in<0> VGND LELO_GR02
XD1<0> VGND ui_in<0> sky130_fd_pr__diode_pw2nd_05v5 area=2.025e11 perim=1.8e6
.ends

* expanding   symbol:  JNW_TR_SKY130A/JNWTR_TAPCELLB_CV.sym # of pins=2
** sym_path: /Users/wulff/data/2023/aicex/ip/lelo_gr02_sky130a/design/JNW_TR_SKY130A/JNWTR_TAPCELLB_CV.sym
** sch_path: /Users/wulff/data/2023/aicex/ip/lelo_gr02_sky130a/design/JNW_TR_SKY130A/JNWTR_TAPCELLB_CV.sch
.subckt JNWTR_TAPCELLB_CV AVDD AVSS
*.iopin AVDD
*.iopin AVSS
XMN1 AVSS AVSS AVSS AVSS JNWTR_NCHDL
XMP1 AVDD AVDD AVDD AVDD JNWTR_PCHDL
.ends

* expanding   symbol:  JNW_TR_SKY130A/JNWTR_TIEL_CV.sym # of pins=3
** sym_path: /Users/wulff/data/2023/aicex/ip/lelo_gr02_sky130a/design/JNW_TR_SKY130A/JNWTR_TIEL_CV.sym
** sch_path: /Users/wulff/data/2023/aicex/ip/lelo_gr02_sky130a/design/JNW_TR_SKY130A/JNWTR_TIEL_CV.sch
.subckt JNWTR_TIEL_CV Y AVDD AVSS
*.iopin Y
*.iopin AVDD
*.iopin AVSS
XMN0 Y A AVSS AVSS JNWTR_NCHDL
XMP0 A A AVDD AVDD JNWTR_PCHDL
.ends

* expanding   symbol:  LELO_GR02_SKY130A/LELO_GR02.sym # of pins=4
** sym_path: /Users/wulff/data/2023/aicex/ip/lelo_gr02_sky130a/design/LELO_GR02_SKY130A/LELO_GR02.sym
** sch_path: /Users/wulff/data/2023/aicex/ip/lelo_gr02_sky130a/design/LELO_GR02_SKY130A/LELO_GR02.sch
.subckt LELO_GR02 VDD_1V8 OSC_TEMP_1V8 PWRUP_1V8 VSS
*.ipin VSS
*.ipin PWRUP_1V8
*.opin OSC_TEMP_1V8
*.ipin VDD_1V8
x1 VDD_1V8 net2 net1 PWRUP_N_1V8 VSS BANDGAP
x2 OSC_TEMP_1V8 VDD_1V8 PWRUP_N_1V8 VSS net1 net2 PWRUP_B_1V8 OSCILLATOR
x6 PWRUP_1V8 PWRUP_N_1V8 VDD_1V8 VSS JNWTR_IVX1_CV
x3 PWRUP_N_1V8 PWRUP_B_1V8 VDD_1V8 VSS JNWTR_IVX1_CV
.ends

* expanding   symbol:  JNW_TR_SKY130A/JNWTR_NCHDL.sym # of pins=4
** sym_path: /Users/wulff/data/2023/aicex/ip/lelo_gr02_sky130a/design/JNW_TR_SKY130A/JNWTR_NCHDL.sym
** sch_path: /Users/wulff/data/2023/aicex/ip/lelo_gr02_sky130a/design/JNW_TR_SKY130A/JNWTR_NCHDL.sch
.subckt JNWTR_NCHDL D G S B
*.iopin D
*.iopin G
*.iopin S
*.iopin B
XM1 D G S B sky130_fd_pr__nfet_01v8 L=0.16 W=0.9 nf=1 ad='int((nf+1)/2) * W/nf * 0.29' as='int((nf+2)/2) * W/nf * 0.29' pd='2*int((nf+1)/2) * (W/nf + 0.29)'
+ ps='2*int((nf+2)/2) * (W/nf + 0.29)' nrd='0.29 / W' nrs='0.29 / W' sa=0 sb=0 sd=0 mult=1 m=1
.ends

* expanding   symbol:  JNW_TR_SKY130A/JNWTR_PCHDL.sym # of pins=4
** sym_path: /Users/wulff/data/2023/aicex/ip/lelo_gr02_sky130a/design/JNW_TR_SKY130A/JNWTR_PCHDL.sym
** sch_path: /Users/wulff/data/2023/aicex/ip/lelo_gr02_sky130a/design/JNW_TR_SKY130A/JNWTR_PCHDL.sch
.subckt JNWTR_PCHDL D G S B
*.iopin D
*.iopin G
*.iopin S
*.iopin B
XM1 D G S B sky130_fd_pr__pfet_01v8 L=0.16 W=0.9 nf=1 ad='int((nf+1)/2) * W/nf * 0.29' as='int((nf+2)/2) * W/nf * 0.29' pd='2*int((nf+1)/2) * (W/nf + 0.29)'
+ ps='2*int((nf+2)/2) * (W/nf + 0.29)' nrd='0.29 / W' nrs='0.29 / W' sa=0 sb=0 sd=0 mult=1 m=1
.ends

* expanding   symbol:  LELO_GR02_SKY130A/BANDGAP.sym # of pins=5
** sym_path: /Users/wulff/data/2023/aicex/ip/lelo_gr02_sky130a/design/LELO_GR02_SKY130A/BANDGAP.sym
** sch_path: /Users/wulff/data/2023/aicex/ip/lelo_gr02_sky130a/design/LELO_GR02_SKY130A/BANDGAP.sch
.subckt BANDGAP VDD_1V8 I_PTAT V_CTAT PWRUP_N_1V8 VSS
*.ipin VDD_1V8
*.ipin VSS
*.opin I_PTAT
*.opin V_CTAT
*.ipin PWRUP_N_1V8
x8 V_CTAT net1 VSS BANDGAP_DIODE
x2 PWRUP_N_1V8 VSS V_CTAT net2 Vout VDD_1V8 BANDGAP_OPAMP
x3 V_CTAT Vout POWERGATING_PMOS VDD_1V8 LELOATR_PCH_2C1F2
x3<1> I_PTAT Vout POWERGATING_PMOS VDD_1V8 LELOATR_PCH_2C1F2
x3<0> I_PTAT Vout POWERGATING_PMOS VDD_1V8 LELOATR_PCH_2C1F2
x4 net2 Vout POWERGATING_PMOS VDD_1V8 LELOATR_PCH_2C1F2
x5 POWERGATING_PMOS Vout JNWTR_CAPX1
x1 net1 net2 VSS JNWTR_RPPO8
x6 POWERGATING_PMOS PWRUP_N_1V8 VDD_1V8 VDD_1V8 JNWATR_PCH_8C1F2
.ends

* expanding   symbol:  LELO_GR02_SKY130A/OSCILLATOR.sym # of pins=7
** sym_path: /Users/wulff/data/2023/aicex/ip/lelo_gr02_sky130a/design/LELO_GR02_SKY130A/OSCILLATOR.sym
** sch_path: /Users/wulff/data/2023/aicex/ip/lelo_gr02_sky130a/design/LELO_GR02_SKY130A/OSCILLATOR.sch
.subckt OSCILLATOR OSC_TEMP_1V8 VDD_1V8 PWRUP_N_1V8 VSS V_CTAT I_PTAT PWRUP_B_1V8
*.ipin PWRUP_B_1V8
*.opin OSC_TEMP_1V8
*.ipin PWRUP_N_1V8
*.ipin VDD_1V8
*.ipin VSS
*.ipin V_CTAT
*.ipin I_PTAT
x6 net1 net3 PWRUP_B_1V8 OSC_TEMP_1V8 net1 VDD_1V8 VSS JNWTR_DFRNQNX1_CV
x13<2> I_PTAT net2 JNWTR_CAPX4
x13<1> I_PTAT net2 JNWTR_CAPX4
x13<0> I_PTAT net2 JNWTR_CAPX4
x3 net2 net3 I_PTAT VSS JNWATR_NCH_2C5F0
x1 net2 PWRUP_B_1V8 VSS VSS JNWATR_NCH_8C1F2
x5 VDD_1V8 PWRUP_N_1V8 VSS I_PTAT V_CTAT net3 COMPARATOR
x2 net3 PWRUP_N_1V8 VSS VSS JNWATR_NCH_8C1F2
.ends

* expanding   symbol:  JNW_TR_SKY130A/JNWTR_IVX1_CV.sym # of pins=4
** sym_path: /Users/wulff/data/2023/aicex/ip/lelo_gr02_sky130a/design/JNW_TR_SKY130A/JNWTR_IVX1_CV.sym
** sch_path: /Users/wulff/data/2023/aicex/ip/lelo_gr02_sky130a/design/JNW_TR_SKY130A/JNWTR_IVX1_CV.sch
.subckt JNWTR_IVX1_CV A Y AVDD AVSS
*.ipin A
*.opin Y
*.ipin AVDD
*.ipin AVSS
XMN0 Y A AVSS AVSS JNWTR_NCHDL
XMP0 Y A AVDD AVDD JNWTR_PCHDL
.ends

* expanding   symbol:  LELO_GR02_SKY130A/BANDGAP_DIODE.sym # of pins=3
** sym_path: /Users/wulff/data/2023/aicex/ip/lelo_gr02_sky130a/design/LELO_GR02_SKY130A/BANDGAP_DIODE.sym
** sch_path: /Users/wulff/data/2023/aicex/ip/lelo_gr02_sky130a/design/LELO_GR02_SKY130A/BANDGAP_DIODE.sch
.subckt BANDGAP_DIODE D1 DN C
*.ipin C
*.ipin D1
*.ipin DN
XQ1 C C D1 sky130_fd_pr__pnp_05v5_W3p40L3p40 m=1 mult=1
XQ2<7> C C DN sky130_fd_pr__pnp_05v5_W3p40L3p40 m=1 mult=1
XQ2<6> C C DN sky130_fd_pr__pnp_05v5_W3p40L3p40 m=1 mult=1
XQ2<5> C C DN sky130_fd_pr__pnp_05v5_W3p40L3p40 m=1 mult=1
XQ2<4> C C DN sky130_fd_pr__pnp_05v5_W3p40L3p40 m=1 mult=1
XQ2<3> C C DN sky130_fd_pr__pnp_05v5_W3p40L3p40 m=1 mult=1
XQ2<2> C C DN sky130_fd_pr__pnp_05v5_W3p40L3p40 m=1 mult=1
XQ2<1> C C DN sky130_fd_pr__pnp_05v5_W3p40L3p40 m=1 mult=1
XQ2<0> C C DN sky130_fd_pr__pnp_05v5_W3p40L3p40 m=1 mult=1
.ends

* expanding   symbol:  LELO_GR02_SKY130A/BANDGAP_OPAMP.sym # of pins=6
** sym_path: /Users/wulff/data/2023/aicex/ip/lelo_gr02_sky130a/design/LELO_GR02_SKY130A/BANDGAP_OPAMP.sym
** sch_path: /Users/wulff/data/2023/aicex/ip/lelo_gr02_sky130a/design/LELO_GR02_SKY130A/BANDGAP_OPAMP.sch
.subckt BANDGAP_OPAMP PWRUP_N_1V8 VSS VIN VIP VOUT VDD_1V8
*.ipin VSS
*.ipin PWRUP_N_1V8
*.ipin VIN
*.opin VOUT
*.ipin VIP
*.ipin VDD_1V8
x3<1> net1 VOUT JNWTR_CAPX4
x3<0> net1 VOUT JNWTR_CAPX4
x1<1> BOTTOM V_IB VSS VSS LELOATR_NCH_4C5F0
x1<0> BOTTOM V_IB VSS VSS LELOATR_NCH_4C5F0
x2 V_IB SUPPLY VSS JNWTR_RPPO8
x6 V_IB PWRUP_N_1V8 VSS VSS LELOATR_NCH_8C1F2
x5<1> V_IB V_IB VSS VSS LELOATR_NCH_4C5F0
x5<0> V_IB V_IB VSS VSS LELOATR_NCH_4C5F0
x7<1> VOUT V_IB VSS VSS LELOATR_NCH_4C5F0
x7<0> VOUT V_IB VSS VSS LELOATR_NCH_4C5F0
x8 PMOS_GATE VIN BOTTOM VSS LELOATR_NCH_4C5F0
x11 net1 VIP BOTTOM VSS LELOATR_NCH_4C5F0
x8<3> net1 PMOS_GATE SUPPLY VDD_1V8 LELOATR_PCH_12C5F0
x8<2> net1 PMOS_GATE SUPPLY VDD_1V8 LELOATR_PCH_12C5F0
x8<1> net1 PMOS_GATE SUPPLY VDD_1V8 LELOATR_PCH_12C5F0
x8<0> net1 PMOS_GATE SUPPLY VDD_1V8 LELOATR_PCH_12C5F0
x4<3> VOUT net1 SUPPLY VDD_1V8 LELOATR_PCH_12C5F0
x4<2> VOUT net1 SUPPLY VDD_1V8 LELOATR_PCH_12C5F0
x4<1> VOUT net1 SUPPLY VDD_1V8 LELOATR_PCH_12C5F0
x4<0> VOUT net1 SUPPLY VDD_1V8 LELOATR_PCH_12C5F0
x9<3> PMOS_GATE PMOS_GATE SUPPLY VDD_1V8 LELOATR_PCH_12C5F0
x9<2> PMOS_GATE PMOS_GATE SUPPLY VDD_1V8 LELOATR_PCH_12C5F0
x9<1> PMOS_GATE PMOS_GATE SUPPLY VDD_1V8 LELOATR_PCH_12C5F0
x9<0> PMOS_GATE PMOS_GATE SUPPLY VDD_1V8 LELOATR_PCH_12C5F0
x10 VOUT PWRUP_N_1V8 VSS VSS LELOATR_NCH_8C1F2
x1 SUPPLY PWRUP_N_1V8 VDD_1V8 VDD_1V8 JNWATR_PCH_8C1F2
.ends

* expanding   symbol:  LELO_ATR_SKY130A/LELOATR_PCH_2C1F2.sym # of pins=4
** sym_path: /Users/wulff/data/2023/aicex/ip/lelo_gr02_sky130a/design/LELO_ATR_SKY130A/LELOATR_PCH_2C1F2.sym
** sch_path: /Users/wulff/data/2023/aicex/ip/lelo_gr02_sky130a/design/LELO_ATR_SKY130A/LELOATR_PCH_2C1F2.sch
.subckt LELOATR_PCH_2C1F2 D G S B
*.iopin D
*.iopin G
*.iopin S
*.iopin B
XM1 D G S B sky130_fd_pr__pfet_01v8 L=0.22 W=1.92 nf=2 ad='int((nf+1)/2) * W/nf * 0.29' as='int((nf+2)/2) * W/nf * 0.29' pd='2*int((nf+1)/2) * (W/nf + 0.29)'
+ ps='2*int((nf+2)/2) * (W/nf + 0.29)' nrd='0.29 / W' nrs='0.29 / W' sa=0 sb=0 sd=0 mult=1 m=1
.ends

* expanding   symbol:  JNW_TR_SKY130A/JNWTR_CAPX1.sym # of pins=2
** sym_path: /Users/wulff/data/2023/aicex/ip/lelo_gr02_sky130a/design/JNW_TR_SKY130A/JNWTR_CAPX1.sym
** sch_path: /Users/wulff/data/2023/aicex/ip/lelo_gr02_sky130a/design/JNW_TR_SKY130A/JNWTR_CAPX1.sch
.subckt JNWTR_CAPX1 A B
*.iopin A
*.iopin B
XC1 B A sky130_fd_pr__cap_mim_m3_1 W=5 L=5 MF=1 m=1
.ends

* expanding   symbol:  JNW_TR_SKY130A/JNWTR_RPPO8.sym # of pins=3
** sym_path: /Users/wulff/data/2023/aicex/ip/lelo_gr02_sky130a/design/JNW_TR_SKY130A/JNWTR_RPPO8.sym
** sch_path: /Users/wulff/data/2023/aicex/ip/lelo_gr02_sky130a/design/JNW_TR_SKY130A/JNWTR_RPPO8.sch
.subckt JNWTR_RPPO8 N P B
*.iopin P
*.iopin N
*.iopin B
XXA1 N P B JNWTR_RES8
.ends

* expanding   symbol:  JNW_ATR_SKY130A/JNWATR_PCH_8C1F2.sym # of pins=4
** sym_path: /Users/wulff/data/2023/aicex/ip/lelo_gr02_sky130a/design/JNW_ATR_SKY130A/JNWATR_PCH_8C1F2.sym
** sch_path: /Users/wulff/data/2023/aicex/ip/lelo_gr02_sky130a/design/JNW_ATR_SKY130A/JNWATR_PCH_8C1F2.sch
.subckt JNWATR_PCH_8C1F2 D G S B
*.iopin D
*.iopin G
*.iopin S
*.iopin B
XM1 D G S B sky130_fd_pr__pfet_01v8 L=0.22 W=5.76 nf=2 ad='int((nf+1)/2) * W/nf * 0.29' as='int((nf+2)/2) * W/nf * 0.29' pd='2*int((nf+1)/2) * (W/nf + 0.29)'
+ ps='2*int((nf+2)/2) * (W/nf + 0.29)' nrd='0.29 / W' nrs='0.29 / W' sa=0 sb=0 sd=0 mult=1 m=1
.ends

* expanding   symbol:  JNW_TR_SKY130A/JNWTR_DFRNQNX1_CV.sym # of pins=7
** sym_path: /Users/wulff/data/2023/aicex/ip/lelo_gr02_sky130a/design/JNW_TR_SKY130A/JNWTR_DFRNQNX1_CV.sym
** sch_path: /Users/wulff/data/2023/aicex/ip/lelo_gr02_sky130a/design/JNW_TR_SKY130A/JNWTR_DFRNQNX1_CV.sch
.subckt JNWTR_DFRNQNX1_CV D CK RN Q QN AVDD AVSS
*.iopin D
*.iopin CK
*.iopin RN
*.iopin Q
*.iopin QN
*.iopin AVDD
*.iopin AVSS
XXA0 AVDD AVSS JNWTR_TAPCELLB_CV
XXA1 CK RN CKN AVDD AVSS JNWTR_NDX1_CV
XXA2 CKN CKB AVDD AVSS JNWTR_IVX1_CV
XXA3 D CKN CKB A0 AVDD AVSS JNWTR_IVTRIX1_CV
XXA4 A1 CKB CKN A0 AVDD AVSS JNWTR_IVTRIX1_CV
XXA5 A0 A1 AVDD AVSS JNWTR_IVX1_CV
XXA6 A1 CKB CKN QN AVDD AVSS JNWTR_IVTRIX1_CV
XXA7 Q CKN CKB RN QN AVDD AVSS JNWTR_NDTRIX1_CV
XXA8 QN Q AVDD AVSS JNWTR_IVX1_CV
.ends

* expanding   symbol:  JNW_TR_SKY130A/JNWTR_CAPX4.sym # of pins=2
** sym_path: /Users/wulff/data/2023/aicex/ip/lelo_gr02_sky130a/design/JNW_TR_SKY130A/JNWTR_CAPX4.sym
** sch_path: /Users/wulff/data/2023/aicex/ip/lelo_gr02_sky130a/design/JNW_TR_SKY130A/JNWTR_CAPX4.sch
.subckt JNWTR_CAPX4 A B
*.iopin A
*.iopin B
XXA1 A B JNWTR_CAPX1
XXA2 A B JNWTR_CAPX1
XXB1 A B JNWTR_CAPX1
XXB2 A B JNWTR_CAPX1
.ends

* expanding   symbol:  JNW_ATR_SKY130A/JNWATR_NCH_2C5F0.sym # of pins=4
** sym_path: /Users/wulff/data/2023/aicex/ip/lelo_gr02_sky130a/design/JNW_ATR_SKY130A/JNWATR_NCH_2C5F0.sym
** sch_path: /Users/wulff/data/2023/aicex/ip/lelo_gr02_sky130a/design/JNW_ATR_SKY130A/JNWATR_NCH_2C5F0.sch
.subckt JNWATR_NCH_2C5F0 D G S B
*.iopin D
*.iopin G
*.iopin S
*.iopin B
XM1 D G S B sky130_fd_pr__nfet_01v8 L=0.94 W=1.92 nf=2 ad='int((nf+1)/2) * W/nf * 0.29' as='int((nf+2)/2) * W/nf * 0.29' pd='2*int((nf+1)/2) * (W/nf + 0.29)'
+ ps='2*int((nf+2)/2) * (W/nf + 0.29)' nrd='0.29 / W' nrs='0.29 / W' sa=0 sb=0 sd=0 mult=1 m=1
.ends

* expanding   symbol:  JNW_ATR_SKY130A/JNWATR_NCH_8C1F2.sym # of pins=4
** sym_path: /Users/wulff/data/2023/aicex/ip/lelo_gr02_sky130a/design/JNW_ATR_SKY130A/JNWATR_NCH_8C1F2.sym
** sch_path: /Users/wulff/data/2023/aicex/ip/lelo_gr02_sky130a/design/JNW_ATR_SKY130A/JNWATR_NCH_8C1F2.sch
.subckt JNWATR_NCH_8C1F2 D G S B
*.iopin D
*.iopin G
*.iopin S
*.iopin B
XM1 D G S B sky130_fd_pr__nfet_01v8 L=0.22 W=5.76 nf=2 ad='int((nf+1)/2) * W/nf * 0.29' as='int((nf+2)/2) * W/nf * 0.29' pd='2*int((nf+1)/2) * (W/nf + 0.29)'
+ ps='2*int((nf+2)/2) * (W/nf + 0.29)' nrd='0.29 / W' nrs='0.29 / W' sa=0 sb=0 sd=0 mult=1 m=1
.ends

* expanding   symbol:  LELO_GR02_SKY130A/COMPARATOR.sym # of pins=6
** sym_path: /Users/wulff/data/2023/aicex/ip/lelo_gr02_sky130a/design/LELO_GR02_SKY130A/COMPARATOR.sym
** sch_path: /Users/wulff/data/2023/aicex/ip/lelo_gr02_sky130a/design/LELO_GR02_SKY130A/COMPARATOR.sch
.subckt COMPARATOR VDD_1V8 PWRUP_N_1V8 VSS VIN_P VIN_N VOUT
*.ipin VDD_1V8
*.ipin VSS
*.ipin PWRUP_N_1V8
*.ipin VIN_P
*.opin VOUT
*.ipin VIN_N
x8 SUPPLY PWRUP_N_1V8 VDD_1V8 VDD_1V8 JNWATR_PCH_8C1F2
x2 V_IB SUPPLY VSS JNWTR_RPPO16
x7 V_IB V_IB VSS VSS JNWATR_NCH_4C5F0
x3 TAIL V_IB VSS VSS JNWATR_NCH_4C5F0
x4 VOUT V_IB VSS VSS JNWATR_NCH_4C5F0
x6 net1 PMOS_GATE SUPPLY VDD_1V8 JNWATR_PCH_4C5F0
x11 PMOS_GATE PMOS_GATE SUPPLY VDD_1V8 JNWATR_PCH_4C5F0
x1 VOUT net1 SUPPLY VDD_1V8 LELOATR_LVT_PCH_4C5F0
x2<1> VOUT PWRUP_N_1V8 VSS VSS LELOATR_NCH_8C1F2
x2<0> VOUT PWRUP_N_1V8 VSS VSS LELOATR_NCH_8C1F2
x1<4> PMOS_GATE VIN_N TAIL VSS JNWATR_NCH_4C5F0
x1<3> PMOS_GATE VIN_N TAIL VSS JNWATR_NCH_4C5F0
x1<2> PMOS_GATE VIN_N TAIL VSS JNWATR_NCH_4C5F0
x1<1> PMOS_GATE VIN_N TAIL VSS JNWATR_NCH_4C5F0
x1<0> PMOS_GATE VIN_N TAIL VSS JNWATR_NCH_4C5F0
x9<4> net1 VIN_P TAIL VSS JNWATR_NCH_4C5F0
x9<3> net1 VIN_P TAIL VSS JNWATR_NCH_4C5F0
x9<2> net1 VIN_P TAIL VSS JNWATR_NCH_4C5F0
x9<1> net1 VIN_P TAIL VSS JNWATR_NCH_4C5F0
x9<0> net1 VIN_P TAIL VSS JNWATR_NCH_4C5F0
x3<1> V_IB PWRUP_N_1V8 VSS VSS LELOATR_NCH_8C1F2
x3<0> V_IB PWRUP_N_1V8 VSS VSS LELOATR_NCH_8C1F2
.ends

* expanding   symbol:  LELO_ATR_SKY130A/LELOATR_NCH_4C5F0.sym # of pins=4
** sym_path: /Users/wulff/data/2023/aicex/ip/lelo_gr02_sky130a/design/LELO_ATR_SKY130A/LELOATR_NCH_4C5F0.sym
** sch_path: /Users/wulff/data/2023/aicex/ip/lelo_gr02_sky130a/design/LELO_ATR_SKY130A/LELOATR_NCH_4C5F0.sch
.subckt LELOATR_NCH_4C5F0 D G S B
*.iopin D
*.iopin G
*.iopin S
*.iopin B
XM1 D G S B sky130_fd_pr__nfet_01v8 L=0.94 W=3.2 nf=2 ad='int((nf+1)/2) * W/nf * 0.29' as='int((nf+2)/2) * W/nf * 0.29' pd='2*int((nf+1)/2) * (W/nf + 0.29)'
+ ps='2*int((nf+2)/2) * (W/nf + 0.29)' nrd='0.29 / W' nrs='0.29 / W' sa=0 sb=0 sd=0 mult=1 m=1
.ends

* expanding   symbol:  LELO_ATR_SKY130A/LELOATR_NCH_8C1F2.sym # of pins=4
** sym_path: /Users/wulff/data/2023/aicex/ip/lelo_gr02_sky130a/design/LELO_ATR_SKY130A/LELOATR_NCH_8C1F2.sym
** sch_path: /Users/wulff/data/2023/aicex/ip/lelo_gr02_sky130a/design/LELO_ATR_SKY130A/LELOATR_NCH_8C1F2.sch
.subckt LELOATR_NCH_8C1F2 D G S B
*.iopin D
*.iopin G
*.iopin S
*.iopin B
XM1 D G S B sky130_fd_pr__nfet_01v8 L=0.22 W=5.76 nf=2 ad='int((nf+1)/2) * W/nf * 0.29' as='int((nf+2)/2) * W/nf * 0.29' pd='2*int((nf+1)/2) * (W/nf + 0.29)'
+ ps='2*int((nf+2)/2) * (W/nf + 0.29)' nrd='0.29 / W' nrs='0.29 / W' sa=0 sb=0 sd=0 mult=1 m=1
.ends

* expanding   symbol:  LELO_ATR_SKY130A/LELOATR_PCH_12C5F0.sym # of pins=4
** sym_path: /Users/wulff/data/2023/aicex/ip/lelo_gr02_sky130a/design/LELO_ATR_SKY130A/LELOATR_PCH_12C5F0.sym
** sch_path: /Users/wulff/data/2023/aicex/ip/lelo_gr02_sky130a/design/LELO_ATR_SKY130A/LELOATR_PCH_12C5F0.sch
.subckt LELOATR_PCH_12C5F0 D G S B
*.iopin D
*.iopin G
*.iopin S
*.iopin B
XM1 D G S B sky130_fd_pr__pfet_01v8 L=0.94 W=8.32 nf=2 ad='int((nf+1)/2) * W/nf * 0.29' as='int((nf+2)/2) * W/nf * 0.29' pd='2*int((nf+1)/2) * (W/nf + 0.29)'
+ ps='2*int((nf+2)/2) * (W/nf + 0.29)' nrd='0.29 / W' nrs='0.29 / W' sa=0 sb=0 sd=0 mult=1 m=1
.ends

* expanding   symbol:  JNW_TR_SKY130A/JNWTR_RES8.sym # of pins=3
** sym_path: /Users/wulff/data/2023/aicex/ip/lelo_gr02_sky130a/design/JNW_TR_SKY130A/JNWTR_RES8.sym
** sch_path: /Users/wulff/data/2023/aicex/ip/lelo_gr02_sky130a/design/JNW_TR_SKY130A/JNWTR_RES8.sch
.subckt JNWTR_RES8 N P B
*.iopin N
*.iopin P
*.iopin B
XR1_0 INT_0 N B sky130_fd_pr__res_high_po W=0.36 L=7.36 mult=1 m=1
XR1_1 INT_1 INT_0 B sky130_fd_pr__res_high_po W=0.36 L=7.36 mult=1 m=1
XR1_2 INT_2 INT_1 B sky130_fd_pr__res_high_po W=0.36 L=7.36 mult=1 m=1
XR1_3 INT_3 INT_2 B sky130_fd_pr__res_high_po W=0.36 L=7.36 mult=1 m=1
XR1_4 INT_4 INT_3 B sky130_fd_pr__res_high_po W=0.36 L=7.36 mult=1 m=1
XR1_5 INT_5 INT_4 B sky130_fd_pr__res_high_po W=0.36 L=7.36 mult=1 m=1
XR1_6 INT_6 INT_5 B sky130_fd_pr__res_high_po W=0.36 L=7.36 mult=1 m=1
XR1_7 P INT_6 B sky130_fd_pr__res_high_po W=0.36 L=7.36 mult=1 m=1
.ends

* expanding   symbol:  JNW_TR_SKY130A/JNWTR_NDX1_CV.sym # of pins=5
** sym_path: /Users/wulff/data/2023/aicex/ip/lelo_gr02_sky130a/design/JNW_TR_SKY130A/JNWTR_NDX1_CV.sym
** sch_path: /Users/wulff/data/2023/aicex/ip/lelo_gr02_sky130a/design/JNW_TR_SKY130A/JNWTR_NDX1_CV.sch
.subckt JNWTR_NDX1_CV A B Y AVDD AVSS
*.iopin A
*.iopin B
*.iopin Y
*.iopin AVDD
*.iopin AVSS
XMN0 N1 A AVSS AVSS JNWTR_NCHDL
XMN1 Y B N1 AVSS JNWTR_NCHDL
XMP0 Y A AVDD AVDD JNWTR_PCHDL
XMP1 AVDD B Y AVDD JNWTR_PCHDL
.ends

* expanding   symbol:  JNW_TR_SKY130A/JNWTR_IVTRIX1_CV.sym # of pins=6
** sym_path: /Users/wulff/data/2023/aicex/ip/lelo_gr02_sky130a/design/JNW_TR_SKY130A/JNWTR_IVTRIX1_CV.sym
** sch_path: /Users/wulff/data/2023/aicex/ip/lelo_gr02_sky130a/design/JNW_TR_SKY130A/JNWTR_IVTRIX1_CV.sch
.subckt JNWTR_IVTRIX1_CV A C CN Y AVDD AVSS
*.iopin A
*.iopin C
*.iopin CN
*.iopin Y
*.iopin AVDD
*.iopin AVSS
XMN0 N1 A AVSS AVSS JNWTR_NCHDL
XMN1 Y C N1 AVSS JNWTR_NCHDL
XMP0 N2 A AVDD AVDD JNWTR_PCHDL
XMP1 Y CN N2 AVDD JNWTR_PCHDL
.ends

* expanding   symbol:  JNW_TR_SKY130A/JNWTR_NDTRIX1_CV.sym # of pins=7
** sym_path: /Users/wulff/data/2023/aicex/ip/lelo_gr02_sky130a/design/JNW_TR_SKY130A/JNWTR_NDTRIX1_CV.sym
** sch_path: /Users/wulff/data/2023/aicex/ip/lelo_gr02_sky130a/design/JNW_TR_SKY130A/JNWTR_NDTRIX1_CV.sch
.subckt JNWTR_NDTRIX1_CV A C CN RN Y AVDD AVSS
*.iopin A
*.iopin C
*.iopin CN
*.iopin RN
*.iopin Y
*.iopin AVDD
*.iopin AVSS
XMN2 N1 RN AVSS AVSS JNWTR_NCHDL
XMN0 N2 A N1 AVSS JNWTR_NCHDL
XMN1 Y C N2 AVSS JNWTR_NCHDL
XMP2 AVDD RN N2 AVDD JNWTR_PCHDL
XMP0 N2 A AVDD AVDD JNWTR_PCHDL
XMP1 Y CN N2 AVDD JNWTR_PCHDL
.ends

* expanding   symbol:  JNW_TR_SKY130A/JNWTR_RPPO16.sym # of pins=3
** sym_path: /Users/wulff/data/2023/aicex/ip/lelo_gr02_sky130a/design/JNW_TR_SKY130A/JNWTR_RPPO16.sym
** sch_path: /Users/wulff/data/2023/aicex/ip/lelo_gr02_sky130a/design/JNW_TR_SKY130A/JNWTR_RPPO16.sch
.subckt JNWTR_RPPO16 N P B
*.iopin P
*.iopin N
*.iopin B
XXA1 N P B JNWTR_RES16
.ends

* expanding   symbol:  JNW_ATR_SKY130A/JNWATR_NCH_4C5F0.sym # of pins=4
** sym_path: /Users/wulff/data/2023/aicex/ip/lelo_gr02_sky130a/design/JNW_ATR_SKY130A/JNWATR_NCH_4C5F0.sym
** sch_path: /Users/wulff/data/2023/aicex/ip/lelo_gr02_sky130a/design/JNW_ATR_SKY130A/JNWATR_NCH_4C5F0.sch
.subckt JNWATR_NCH_4C5F0 D G S B
*.iopin D
*.iopin G
*.iopin S
*.iopin B
XM1 D G S B sky130_fd_pr__nfet_01v8 L=0.94 W=3.2 nf=2 ad='int((nf+1)/2) * W/nf * 0.29' as='int((nf+2)/2) * W/nf * 0.29' pd='2*int((nf+1)/2) * (W/nf + 0.29)'
+ ps='2*int((nf+2)/2) * (W/nf + 0.29)' nrd='0.29 / W' nrs='0.29 / W' sa=0 sb=0 sd=0 mult=1 m=1
.ends

* expanding   symbol:  JNW_ATR_SKY130A/JNWATR_PCH_4C5F0.sym # of pins=4
** sym_path: /Users/wulff/data/2023/aicex/ip/lelo_gr02_sky130a/design/JNW_ATR_SKY130A/JNWATR_PCH_4C5F0.sym
** sch_path: /Users/wulff/data/2023/aicex/ip/lelo_gr02_sky130a/design/JNW_ATR_SKY130A/JNWATR_PCH_4C5F0.sch
.subckt JNWATR_PCH_4C5F0 D G S B
*.iopin D
*.iopin G
*.iopin S
*.iopin B
XM1 D G S B sky130_fd_pr__pfet_01v8 L=0.94 W=3.2 nf=2 ad='int((nf+1)/2) * W/nf * 0.29' as='int((nf+2)/2) * W/nf * 0.29' pd='2*int((nf+1)/2) * (W/nf + 0.29)'
+ ps='2*int((nf+2)/2) * (W/nf + 0.29)' nrd='0.29 / W' nrs='0.29 / W' sa=0 sb=0 sd=0 mult=1 m=1
.ends

* expanding   symbol:  LELO_ATR_SKY130A/LELOATR_LVT_PCH_4C5F0.sym # of pins=4
** sym_path: /Users/wulff/data/2023/aicex/ip/lelo_gr02_sky130a/design/LELO_ATR_SKY130A/LELOATR_LVT_PCH_4C5F0.sym
** sch_path: /Users/wulff/data/2023/aicex/ip/lelo_gr02_sky130a/design/LELO_ATR_SKY130A/LELOATR_LVT_PCH_4C5F0.sch
.subckt LELOATR_LVT_PCH_4C5F0 D G S B
*.iopin D
*.iopin G
*.iopin S
*.iopin B
XM1 D G S B sky130_fd_pr__pfet_01v8_lvt L=0.94 W=3.2 nf=2 ad='int((nf+1)/2) * W/nf * 0.29' as='int((nf+2)/2) * W/nf * 0.29' pd='2*int((nf+1)/2) * (W/nf + 0.29)'
+ ps='2*int((nf+2)/2) * (W/nf + 0.29)' nrd='0.29 / W' nrs='0.29 / W' sa=0 sb=0 sd=0 mult=1 m=1
.ends

* expanding   symbol:  JNW_TR_SKY130A/JNWTR_RES16.sym # of pins=3
** sym_path: /Users/wulff/data/2023/aicex/ip/lelo_gr02_sky130a/design/JNW_TR_SKY130A/JNWTR_RES16.sym
** sch_path: /Users/wulff/data/2023/aicex/ip/lelo_gr02_sky130a/design/JNW_TR_SKY130A/JNWTR_RES16.sch
.subckt JNWTR_RES16 N P B
*.iopin N
*.iopin P
*.iopin B
XR1_0 INT_0 N B sky130_fd_pr__res_high_po W=0.36 L=7.36 mult=1 m=1
XR1_1 INT_1 INT_0 B sky130_fd_pr__res_high_po W=0.36 L=7.36 mult=1 m=1
XR1_2 INT_2 INT_1 B sky130_fd_pr__res_high_po W=0.36 L=7.36 mult=1 m=1
XR1_3 INT_3 INT_2 B sky130_fd_pr__res_high_po W=0.36 L=7.36 mult=1 m=1
XR1_4 INT_4 INT_3 B sky130_fd_pr__res_high_po W=0.36 L=7.36 mult=1 m=1
XR1_5 INT_5 INT_4 B sky130_fd_pr__res_high_po W=0.36 L=7.36 mult=1 m=1
XR1_6 INT_6 INT_5 B sky130_fd_pr__res_high_po W=0.36 L=7.36 mult=1 m=1
XR1_7 INT_7 INT_6 B sky130_fd_pr__res_high_po W=0.36 L=7.36 mult=1 m=1
XR1_8 INT_8 INT_7 B sky130_fd_pr__res_high_po W=0.36 L=7.36 mult=1 m=1
XR1_9 INT_9 INT_8 B sky130_fd_pr__res_high_po W=0.36 L=7.36 mult=1 m=1
XR1_10 INT_10 INT_9 B sky130_fd_pr__res_high_po W=0.36 L=7.36 mult=1 m=1
XR1_11 INT_11 INT_10 B sky130_fd_pr__res_high_po W=0.36 L=7.36 mult=1 m=1
XR1_12 INT_12 INT_11 B sky130_fd_pr__res_high_po W=0.36 L=7.36 mult=1 m=1
XR1_13 INT_13 INT_12 B sky130_fd_pr__res_high_po W=0.36 L=7.36 mult=1 m=1
XR1_14 INT_14 INT_13 B sky130_fd_pr__res_high_po W=0.36 L=7.36 mult=1 m=1
XR1_15 P INT_14 B sky130_fd_pr__res_high_po W=0.36 L=7.36 mult=1 m=1
.ends

.end
